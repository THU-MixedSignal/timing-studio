// Timing Wave Studio Desktop — generated Verilog-A stimulus.
// Edge positions are transition START times, not threshold crossings.
// Short tracks hold to the macroperiod; finite runs hold final levels.
// Finite runs ignore later timer events; periodic timers keep waking.
// Waveform edges use event schedules, never dense samples.
// time_scale scales every event time and the rise/fall durations.
// Connect vref to the intended voltage reference (usually ground).
// Transient/open-loop use. PSS/PAC and feedback are not validated.
`include "constants.vams"
`include "disciplines.vams"

module timing_collaboration_demo(reset, clk, phi1, phi2, sample, done, vref);
  output reset, clk, phi1, phi2, sample, done;
  input vref;
  electrical reset, clk, phi1, phi2, sample, done, vref;

  parameter real vlow = 0.0;
  parameter real vhigh = 1.0 from (vlow:inf);
  parameter real trise = 200000e-15 from (0:inf);
  parameter real tfall = 200000e-15 from (0:inf);
  parameter real time_scale = 1.0 from (0:inf);
  parameter integer cycles = 0 from [0:1000000000]; // 0 = forever

  integer _tw_level_0;
  integer _tw_count_0;
  integer _tw_count_1;
  integer _tw_level_1;
  integer _tw_count_2;
  integer _tw_count_3;
  integer _tw_count_4;
  integer _tw_count_5;
  integer _tw_count_6;
  integer _tw_count_7;
  integer _tw_count_8;
  integer _tw_count_9;
  integer _tw_count_10;
  integer _tw_count_11;
  integer _tw_count_12;
  integer _tw_count_13;
  integer _tw_count_14;
  integer _tw_count_15;
  integer _tw_count_16;
  integer _tw_count_17;
  integer _tw_count_18;
  integer _tw_count_19;
  integer _tw_count_20;
  integer _tw_count_21;
  integer _tw_count_22;
  integer _tw_count_23;
  integer _tw_count_24;
  integer _tw_count_25;
  integer _tw_count_26;
  integer _tw_count_27;
  integer _tw_count_28;
  integer _tw_count_29;
  integer _tw_count_30;
  integer _tw_count_31;
  integer _tw_count_32;
  integer _tw_count_33;
  integer _tw_count_34;
  integer _tw_count_35;
  integer _tw_count_36;
  integer _tw_count_37;
  integer _tw_count_38;
  integer _tw_count_39;
  integer _tw_count_40;
  integer _tw_count_41;
  integer _tw_count_42;
  integer _tw_count_43;
  integer _tw_count_44;
  integer _tw_count_45;
  integer _tw_count_46;
  integer _tw_count_47;
  integer _tw_count_48;
  integer _tw_count_49;
  integer _tw_count_50;
  integer _tw_count_51;
  integer _tw_count_52;
  integer _tw_count_53;
  integer _tw_count_54;
  integer _tw_count_55;
  integer _tw_count_56;
  integer _tw_count_57;
  integer _tw_count_58;
  integer _tw_count_59;
  integer _tw_count_60;
  integer _tw_count_61;
  integer _tw_count_62;
  integer _tw_count_63;
  integer _tw_count_64;
  integer _tw_count_65;
  integer _tw_count_66;
  integer _tw_count_67;
  integer _tw_count_68;
  integer _tw_count_69;
  integer _tw_count_70;
  integer _tw_count_71;
  integer _tw_count_72;
  integer _tw_count_73;
  integer _tw_count_74;
  integer _tw_count_75;
  integer _tw_count_76;
  integer _tw_count_77;
  integer _tw_count_78;
  integer _tw_count_79;
  integer _tw_count_80;
  integer _tw_count_81;
  integer _tw_count_82;
  integer _tw_count_83;
  integer _tw_count_84;
  integer _tw_count_85;
  integer _tw_count_86;
  integer _tw_count_87;
  integer _tw_count_88;
  integer _tw_count_89;
  integer _tw_count_90;
  integer _tw_count_91;
  integer _tw_count_92;
  integer _tw_count_93;
  integer _tw_count_94;
  integer _tw_count_95;
  integer _tw_count_96;
  integer _tw_count_97;
  integer _tw_count_98;
  integer _tw_count_99;
  integer _tw_count_100;
  integer _tw_count_101;
  integer _tw_count_102;
  integer _tw_count_103;
  integer _tw_count_104;
  integer _tw_count_105;
  integer _tw_count_106;
  integer _tw_count_107;
  integer _tw_count_108;
  integer _tw_count_109;
  integer _tw_count_110;
  integer _tw_count_111;
  integer _tw_count_112;
  integer _tw_count_113;
  integer _tw_count_114;
  integer _tw_count_115;
  integer _tw_count_116;
  integer _tw_count_117;
  integer _tw_count_118;
  integer _tw_count_119;
  integer _tw_count_120;
  integer _tw_count_121;
  integer _tw_count_122;
  integer _tw_count_123;
  integer _tw_count_124;
  integer _tw_count_125;
  integer _tw_count_126;
  integer _tw_count_127;
  integer _tw_count_128;
  integer _tw_count_129;
  integer _tw_count_130;
  integer _tw_count_131;
  integer _tw_count_132;
  integer _tw_count_133;
  integer _tw_count_134;
  integer _tw_count_135;
  integer _tw_count_136;
  integer _tw_count_137;
  integer _tw_count_138;
  integer _tw_count_139;
  integer _tw_count_140;
  integer _tw_count_141;
  integer _tw_count_142;
  integer _tw_count_143;
  integer _tw_count_144;
  integer _tw_count_145;
  integer _tw_count_146;
  integer _tw_count_147;
  integer _tw_count_148;
  integer _tw_count_149;
  integer _tw_count_150;
  integer _tw_count_151;
  integer _tw_count_152;
  integer _tw_count_153;
  integer _tw_count_154;
  integer _tw_count_155;
  integer _tw_count_156;
  integer _tw_count_157;
  integer _tw_count_158;
  integer _tw_count_159;
  integer _tw_count_160;
  integer _tw_count_161;
  integer _tw_count_162;
  integer _tw_count_163;
  integer _tw_count_164;
  integer _tw_count_165;
  integer _tw_count_166;
  integer _tw_count_167;
  integer _tw_count_168;
  integer _tw_count_169;
  integer _tw_count_170;
  integer _tw_count_171;
  integer _tw_count_172;
  integer _tw_count_173;
  integer _tw_count_174;
  integer _tw_count_175;
  integer _tw_count_176;
  integer _tw_count_177;
  integer _tw_count_178;
  integer _tw_count_179;
  integer _tw_count_180;
  integer _tw_count_181;
  integer _tw_count_182;
  integer _tw_count_183;
  integer _tw_count_184;
  integer _tw_count_185;
  integer _tw_count_186;
  integer _tw_count_187;
  integer _tw_count_188;
  integer _tw_count_189;
  integer _tw_count_190;
  integer _tw_count_191;
  integer _tw_count_192;
  integer _tw_count_193;
  integer _tw_count_194;
  integer _tw_count_195;
  integer _tw_count_196;
  integer _tw_count_197;
  integer _tw_count_198;
  integer _tw_count_199;
  integer _tw_count_200;
  integer _tw_count_201;
  integer _tw_level_2;
  integer _tw_count_202;
  integer _tw_count_203;
  integer _tw_count_204;
  integer _tw_count_205;
  integer _tw_count_206;
  integer _tw_count_207;
  integer _tw_count_208;
  integer _tw_count_209;
  integer _tw_count_210;
  integer _tw_count_211;
  integer _tw_count_212;
  integer _tw_count_213;
  integer _tw_count_214;
  integer _tw_count_215;
  integer _tw_count_216;
  integer _tw_count_217;
  integer _tw_count_218;
  integer _tw_count_219;
  integer _tw_count_220;
  integer _tw_count_221;
  integer _tw_count_222;
  integer _tw_count_223;
  integer _tw_count_224;
  integer _tw_count_225;
  integer _tw_count_226;
  integer _tw_count_227;
  integer _tw_count_228;
  integer _tw_count_229;
  integer _tw_count_230;
  integer _tw_count_231;
  integer _tw_count_232;
  integer _tw_count_233;
  integer _tw_count_234;
  integer _tw_count_235;
  integer _tw_count_236;
  integer _tw_count_237;
  integer _tw_count_238;
  integer _tw_count_239;
  integer _tw_count_240;
  integer _tw_count_241;
  integer _tw_count_242;
  integer _tw_count_243;
  integer _tw_count_244;
  integer _tw_count_245;
  integer _tw_count_246;
  integer _tw_count_247;
  integer _tw_count_248;
  integer _tw_count_249;
  integer _tw_count_250;
  integer _tw_count_251;
  integer _tw_count_252;
  integer _tw_count_253;
  integer _tw_count_254;
  integer _tw_count_255;
  integer _tw_count_256;
  integer _tw_count_257;
  integer _tw_count_258;
  integer _tw_count_259;
  integer _tw_count_260;
  integer _tw_count_261;
  integer _tw_count_262;
  integer _tw_count_263;
  integer _tw_count_264;
  integer _tw_count_265;
  integer _tw_count_266;
  integer _tw_count_267;
  integer _tw_count_268;
  integer _tw_count_269;
  integer _tw_count_270;
  integer _tw_count_271;
  integer _tw_count_272;
  integer _tw_count_273;
  integer _tw_count_274;
  integer _tw_count_275;
  integer _tw_count_276;
  integer _tw_count_277;
  integer _tw_count_278;
  integer _tw_count_279;
  integer _tw_count_280;
  integer _tw_count_281;
  integer _tw_count_282;
  integer _tw_count_283;
  integer _tw_count_284;
  integer _tw_count_285;
  integer _tw_count_286;
  integer _tw_count_287;
  integer _tw_count_288;
  integer _tw_count_289;
  integer _tw_count_290;
  integer _tw_count_291;
  integer _tw_count_292;
  integer _tw_count_293;
  integer _tw_count_294;
  integer _tw_count_295;
  integer _tw_count_296;
  integer _tw_count_297;
  integer _tw_count_298;
  integer _tw_count_299;
  integer _tw_count_300;
  integer _tw_count_301;
  integer _tw_count_302;
  integer _tw_count_303;
  integer _tw_count_304;
  integer _tw_count_305;
  integer _tw_count_306;
  integer _tw_count_307;
  integer _tw_count_308;
  integer _tw_count_309;
  integer _tw_count_310;
  integer _tw_count_311;
  integer _tw_count_312;
  integer _tw_count_313;
  integer _tw_count_314;
  integer _tw_count_315;
  integer _tw_count_316;
  integer _tw_count_317;
  integer _tw_count_318;
  integer _tw_count_319;
  integer _tw_count_320;
  integer _tw_count_321;
  integer _tw_count_322;
  integer _tw_count_323;
  integer _tw_count_324;
  integer _tw_count_325;
  integer _tw_count_326;
  integer _tw_count_327;
  integer _tw_count_328;
  integer _tw_count_329;
  integer _tw_count_330;
  integer _tw_count_331;
  integer _tw_count_332;
  integer _tw_count_333;
  integer _tw_count_334;
  integer _tw_count_335;
  integer _tw_count_336;
  integer _tw_count_337;
  integer _tw_count_338;
  integer _tw_count_339;
  integer _tw_count_340;
  integer _tw_count_341;
  integer _tw_count_342;
  integer _tw_count_343;
  integer _tw_count_344;
  integer _tw_count_345;
  integer _tw_count_346;
  integer _tw_count_347;
  integer _tw_count_348;
  integer _tw_count_349;
  integer _tw_count_350;
  integer _tw_count_351;
  integer _tw_count_352;
  integer _tw_count_353;
  integer _tw_count_354;
  integer _tw_count_355;
  integer _tw_count_356;
  integer _tw_count_357;
  integer _tw_count_358;
  integer _tw_count_359;
  integer _tw_count_360;
  integer _tw_count_361;
  integer _tw_count_362;
  integer _tw_count_363;
  integer _tw_count_364;
  integer _tw_count_365;
  integer _tw_count_366;
  integer _tw_count_367;
  integer _tw_count_368;
  integer _tw_count_369;
  integer _tw_count_370;
  integer _tw_count_371;
  integer _tw_count_372;
  integer _tw_count_373;
  integer _tw_count_374;
  integer _tw_count_375;
  integer _tw_count_376;
  integer _tw_count_377;
  integer _tw_count_378;
  integer _tw_count_379;
  integer _tw_count_380;
  integer _tw_count_381;
  integer _tw_count_382;
  integer _tw_count_383;
  integer _tw_count_384;
  integer _tw_count_385;
  integer _tw_count_386;
  integer _tw_count_387;
  integer _tw_count_388;
  integer _tw_count_389;
  integer _tw_count_390;
  integer _tw_count_391;
  integer _tw_count_392;
  integer _tw_count_393;
  integer _tw_count_394;
  integer _tw_count_395;
  integer _tw_count_396;
  integer _tw_count_397;
  integer _tw_count_398;
  integer _tw_count_399;
  integer _tw_count_400;
  integer _tw_count_401;
  integer _tw_level_3;
  integer _tw_count_402;
  integer _tw_count_403;
  integer _tw_count_404;
  integer _tw_count_405;
  integer _tw_count_406;
  integer _tw_count_407;
  integer _tw_count_408;
  integer _tw_count_409;
  integer _tw_count_410;
  integer _tw_count_411;
  integer _tw_count_412;
  integer _tw_count_413;
  integer _tw_count_414;
  integer _tw_count_415;
  integer _tw_count_416;
  integer _tw_count_417;
  integer _tw_count_418;
  integer _tw_count_419;
  integer _tw_count_420;
  integer _tw_count_421;
  integer _tw_count_422;
  integer _tw_count_423;
  integer _tw_count_424;
  integer _tw_count_425;
  integer _tw_count_426;
  integer _tw_count_427;
  integer _tw_count_428;
  integer _tw_count_429;
  integer _tw_count_430;
  integer _tw_count_431;
  integer _tw_count_432;
  integer _tw_count_433;
  integer _tw_count_434;
  integer _tw_count_435;
  integer _tw_count_436;
  integer _tw_count_437;
  integer _tw_count_438;
  integer _tw_count_439;
  integer _tw_count_440;
  integer _tw_count_441;
  integer _tw_count_442;
  integer _tw_count_443;
  integer _tw_count_444;
  integer _tw_count_445;
  integer _tw_count_446;
  integer _tw_count_447;
  integer _tw_count_448;
  integer _tw_count_449;
  integer _tw_count_450;
  integer _tw_count_451;
  integer _tw_count_452;
  integer _tw_count_453;
  integer _tw_count_454;
  integer _tw_count_455;
  integer _tw_count_456;
  integer _tw_count_457;
  integer _tw_count_458;
  integer _tw_count_459;
  integer _tw_count_460;
  integer _tw_count_461;
  integer _tw_count_462;
  integer _tw_count_463;
  integer _tw_count_464;
  integer _tw_count_465;
  integer _tw_count_466;
  integer _tw_count_467;
  integer _tw_count_468;
  integer _tw_count_469;
  integer _tw_count_470;
  integer _tw_count_471;
  integer _tw_count_472;
  integer _tw_count_473;
  integer _tw_count_474;
  integer _tw_count_475;
  integer _tw_count_476;
  integer _tw_count_477;
  integer _tw_count_478;
  integer _tw_count_479;
  integer _tw_count_480;
  integer _tw_count_481;
  integer _tw_count_482;
  integer _tw_count_483;
  integer _tw_count_484;
  integer _tw_count_485;
  integer _tw_count_486;
  integer _tw_count_487;
  integer _tw_count_488;
  integer _tw_count_489;
  integer _tw_count_490;
  integer _tw_count_491;
  integer _tw_count_492;
  integer _tw_count_493;
  integer _tw_count_494;
  integer _tw_count_495;
  integer _tw_count_496;
  integer _tw_count_497;
  integer _tw_count_498;
  integer _tw_count_499;
  integer _tw_count_500;
  integer _tw_count_501;
  integer _tw_count_502;
  integer _tw_count_503;
  integer _tw_count_504;
  integer _tw_count_505;
  integer _tw_count_506;
  integer _tw_count_507;
  integer _tw_count_508;
  integer _tw_count_509;
  integer _tw_count_510;
  integer _tw_count_511;
  integer _tw_count_512;
  integer _tw_count_513;
  integer _tw_count_514;
  integer _tw_count_515;
  integer _tw_count_516;
  integer _tw_count_517;
  integer _tw_count_518;
  integer _tw_count_519;
  integer _tw_count_520;
  integer _tw_count_521;
  integer _tw_count_522;
  integer _tw_count_523;
  integer _tw_count_524;
  integer _tw_count_525;
  integer _tw_count_526;
  integer _tw_count_527;
  integer _tw_count_528;
  integer _tw_count_529;
  integer _tw_count_530;
  integer _tw_count_531;
  integer _tw_count_532;
  integer _tw_count_533;
  integer _tw_count_534;
  integer _tw_count_535;
  integer _tw_count_536;
  integer _tw_count_537;
  integer _tw_count_538;
  integer _tw_count_539;
  integer _tw_count_540;
  integer _tw_count_541;
  integer _tw_count_542;
  integer _tw_count_543;
  integer _tw_count_544;
  integer _tw_count_545;
  integer _tw_count_546;
  integer _tw_count_547;
  integer _tw_count_548;
  integer _tw_count_549;
  integer _tw_count_550;
  integer _tw_count_551;
  integer _tw_count_552;
  integer _tw_count_553;
  integer _tw_count_554;
  integer _tw_count_555;
  integer _tw_count_556;
  integer _tw_count_557;
  integer _tw_count_558;
  integer _tw_count_559;
  integer _tw_count_560;
  integer _tw_count_561;
  integer _tw_count_562;
  integer _tw_count_563;
  integer _tw_count_564;
  integer _tw_count_565;
  integer _tw_count_566;
  integer _tw_count_567;
  integer _tw_count_568;
  integer _tw_count_569;
  integer _tw_count_570;
  integer _tw_count_571;
  integer _tw_count_572;
  integer _tw_count_573;
  integer _tw_count_574;
  integer _tw_count_575;
  integer _tw_count_576;
  integer _tw_count_577;
  integer _tw_count_578;
  integer _tw_count_579;
  integer _tw_count_580;
  integer _tw_count_581;
  integer _tw_count_582;
  integer _tw_count_583;
  integer _tw_count_584;
  integer _tw_count_585;
  integer _tw_count_586;
  integer _tw_count_587;
  integer _tw_count_588;
  integer _tw_count_589;
  integer _tw_count_590;
  integer _tw_count_591;
  integer _tw_count_592;
  integer _tw_count_593;
  integer _tw_count_594;
  integer _tw_count_595;
  integer _tw_count_596;
  integer _tw_count_597;
  integer _tw_count_598;
  integer _tw_count_599;
  integer _tw_count_600;
  integer _tw_count_601;
  integer _tw_level_4;
  integer _tw_count_602;
  integer _tw_count_603;
  integer _tw_count_604;
  integer _tw_count_605;
  integer _tw_level_5;
  integer _tw_count_606;
  integer _tw_count_607;

  analog begin
    @(initial_step) begin
      _tw_level_0 = 1; // reset
      _tw_level_1 = 0; // clk
      _tw_level_2 = 0; // phi1
      _tw_level_3 = 0; // phi2
      _tw_level_4 = 0; // sample
      _tw_level_5 = 0; // done
      _tw_count_0 = 0;
      _tw_count_1 = 1;
      _tw_count_2 = 0;
      _tw_count_3 = 0;
      _tw_count_4 = 0;
      _tw_count_5 = 0;
      _tw_count_6 = 0;
      _tw_count_7 = 0;
      _tw_count_8 = 0;
      _tw_count_9 = 0;
      _tw_count_10 = 0;
      _tw_count_11 = 0;
      _tw_count_12 = 0;
      _tw_count_13 = 0;
      _tw_count_14 = 0;
      _tw_count_15 = 0;
      _tw_count_16 = 0;
      _tw_count_17 = 0;
      _tw_count_18 = 0;
      _tw_count_19 = 0;
      _tw_count_20 = 0;
      _tw_count_21 = 0;
      _tw_count_22 = 0;
      _tw_count_23 = 0;
      _tw_count_24 = 0;
      _tw_count_25 = 0;
      _tw_count_26 = 0;
      _tw_count_27 = 0;
      _tw_count_28 = 0;
      _tw_count_29 = 0;
      _tw_count_30 = 0;
      _tw_count_31 = 0;
      _tw_count_32 = 0;
      _tw_count_33 = 0;
      _tw_count_34 = 0;
      _tw_count_35 = 0;
      _tw_count_36 = 0;
      _tw_count_37 = 0;
      _tw_count_38 = 0;
      _tw_count_39 = 0;
      _tw_count_40 = 0;
      _tw_count_41 = 0;
      _tw_count_42 = 0;
      _tw_count_43 = 0;
      _tw_count_44 = 0;
      _tw_count_45 = 0;
      _tw_count_46 = 0;
      _tw_count_47 = 0;
      _tw_count_48 = 0;
      _tw_count_49 = 0;
      _tw_count_50 = 0;
      _tw_count_51 = 0;
      _tw_count_52 = 0;
      _tw_count_53 = 0;
      _tw_count_54 = 0;
      _tw_count_55 = 0;
      _tw_count_56 = 0;
      _tw_count_57 = 0;
      _tw_count_58 = 0;
      _tw_count_59 = 0;
      _tw_count_60 = 0;
      _tw_count_61 = 0;
      _tw_count_62 = 0;
      _tw_count_63 = 0;
      _tw_count_64 = 0;
      _tw_count_65 = 0;
      _tw_count_66 = 0;
      _tw_count_67 = 0;
      _tw_count_68 = 0;
      _tw_count_69 = 0;
      _tw_count_70 = 0;
      _tw_count_71 = 0;
      _tw_count_72 = 0;
      _tw_count_73 = 0;
      _tw_count_74 = 0;
      _tw_count_75 = 0;
      _tw_count_76 = 0;
      _tw_count_77 = 0;
      _tw_count_78 = 0;
      _tw_count_79 = 0;
      _tw_count_80 = 0;
      _tw_count_81 = 0;
      _tw_count_82 = 0;
      _tw_count_83 = 0;
      _tw_count_84 = 0;
      _tw_count_85 = 0;
      _tw_count_86 = 0;
      _tw_count_87 = 0;
      _tw_count_88 = 0;
      _tw_count_89 = 0;
      _tw_count_90 = 0;
      _tw_count_91 = 0;
      _tw_count_92 = 0;
      _tw_count_93 = 0;
      _tw_count_94 = 0;
      _tw_count_95 = 0;
      _tw_count_96 = 0;
      _tw_count_97 = 0;
      _tw_count_98 = 0;
      _tw_count_99 = 0;
      _tw_count_100 = 0;
      _tw_count_101 = 0;
      _tw_count_102 = 0;
      _tw_count_103 = 0;
      _tw_count_104 = 0;
      _tw_count_105 = 0;
      _tw_count_106 = 0;
      _tw_count_107 = 0;
      _tw_count_108 = 0;
      _tw_count_109 = 0;
      _tw_count_110 = 0;
      _tw_count_111 = 0;
      _tw_count_112 = 0;
      _tw_count_113 = 0;
      _tw_count_114 = 0;
      _tw_count_115 = 0;
      _tw_count_116 = 0;
      _tw_count_117 = 0;
      _tw_count_118 = 0;
      _tw_count_119 = 0;
      _tw_count_120 = 0;
      _tw_count_121 = 0;
      _tw_count_122 = 0;
      _tw_count_123 = 0;
      _tw_count_124 = 0;
      _tw_count_125 = 0;
      _tw_count_126 = 0;
      _tw_count_127 = 0;
      _tw_count_128 = 0;
      _tw_count_129 = 0;
      _tw_count_130 = 0;
      _tw_count_131 = 0;
      _tw_count_132 = 0;
      _tw_count_133 = 0;
      _tw_count_134 = 0;
      _tw_count_135 = 0;
      _tw_count_136 = 0;
      _tw_count_137 = 0;
      _tw_count_138 = 0;
      _tw_count_139 = 0;
      _tw_count_140 = 0;
      _tw_count_141 = 0;
      _tw_count_142 = 0;
      _tw_count_143 = 0;
      _tw_count_144 = 0;
      _tw_count_145 = 0;
      _tw_count_146 = 0;
      _tw_count_147 = 0;
      _tw_count_148 = 0;
      _tw_count_149 = 0;
      _tw_count_150 = 0;
      _tw_count_151 = 0;
      _tw_count_152 = 0;
      _tw_count_153 = 0;
      _tw_count_154 = 0;
      _tw_count_155 = 0;
      _tw_count_156 = 0;
      _tw_count_157 = 0;
      _tw_count_158 = 0;
      _tw_count_159 = 0;
      _tw_count_160 = 0;
      _tw_count_161 = 0;
      _tw_count_162 = 0;
      _tw_count_163 = 0;
      _tw_count_164 = 0;
      _tw_count_165 = 0;
      _tw_count_166 = 0;
      _tw_count_167 = 0;
      _tw_count_168 = 0;
      _tw_count_169 = 0;
      _tw_count_170 = 0;
      _tw_count_171 = 0;
      _tw_count_172 = 0;
      _tw_count_173 = 0;
      _tw_count_174 = 0;
      _tw_count_175 = 0;
      _tw_count_176 = 0;
      _tw_count_177 = 0;
      _tw_count_178 = 0;
      _tw_count_179 = 0;
      _tw_count_180 = 0;
      _tw_count_181 = 0;
      _tw_count_182 = 0;
      _tw_count_183 = 0;
      _tw_count_184 = 0;
      _tw_count_185 = 0;
      _tw_count_186 = 0;
      _tw_count_187 = 0;
      _tw_count_188 = 0;
      _tw_count_189 = 0;
      _tw_count_190 = 0;
      _tw_count_191 = 0;
      _tw_count_192 = 0;
      _tw_count_193 = 0;
      _tw_count_194 = 0;
      _tw_count_195 = 0;
      _tw_count_196 = 0;
      _tw_count_197 = 0;
      _tw_count_198 = 0;
      _tw_count_199 = 0;
      _tw_count_200 = 0;
      _tw_count_201 = 0;
      _tw_count_202 = 0;
      _tw_count_203 = 0;
      _tw_count_204 = 0;
      _tw_count_205 = 0;
      _tw_count_206 = 0;
      _tw_count_207 = 0;
      _tw_count_208 = 0;
      _tw_count_209 = 0;
      _tw_count_210 = 0;
      _tw_count_211 = 0;
      _tw_count_212 = 0;
      _tw_count_213 = 0;
      _tw_count_214 = 0;
      _tw_count_215 = 0;
      _tw_count_216 = 0;
      _tw_count_217 = 0;
      _tw_count_218 = 0;
      _tw_count_219 = 0;
      _tw_count_220 = 0;
      _tw_count_221 = 0;
      _tw_count_222 = 0;
      _tw_count_223 = 0;
      _tw_count_224 = 0;
      _tw_count_225 = 0;
      _tw_count_226 = 0;
      _tw_count_227 = 0;
      _tw_count_228 = 0;
      _tw_count_229 = 0;
      _tw_count_230 = 0;
      _tw_count_231 = 0;
      _tw_count_232 = 0;
      _tw_count_233 = 0;
      _tw_count_234 = 0;
      _tw_count_235 = 0;
      _tw_count_236 = 0;
      _tw_count_237 = 0;
      _tw_count_238 = 0;
      _tw_count_239 = 0;
      _tw_count_240 = 0;
      _tw_count_241 = 0;
      _tw_count_242 = 0;
      _tw_count_243 = 0;
      _tw_count_244 = 0;
      _tw_count_245 = 0;
      _tw_count_246 = 0;
      _tw_count_247 = 0;
      _tw_count_248 = 0;
      _tw_count_249 = 0;
      _tw_count_250 = 0;
      _tw_count_251 = 0;
      _tw_count_252 = 0;
      _tw_count_253 = 0;
      _tw_count_254 = 0;
      _tw_count_255 = 0;
      _tw_count_256 = 0;
      _tw_count_257 = 0;
      _tw_count_258 = 0;
      _tw_count_259 = 0;
      _tw_count_260 = 0;
      _tw_count_261 = 0;
      _tw_count_262 = 0;
      _tw_count_263 = 0;
      _tw_count_264 = 0;
      _tw_count_265 = 0;
      _tw_count_266 = 0;
      _tw_count_267 = 0;
      _tw_count_268 = 0;
      _tw_count_269 = 0;
      _tw_count_270 = 0;
      _tw_count_271 = 0;
      _tw_count_272 = 0;
      _tw_count_273 = 0;
      _tw_count_274 = 0;
      _tw_count_275 = 0;
      _tw_count_276 = 0;
      _tw_count_277 = 0;
      _tw_count_278 = 0;
      _tw_count_279 = 0;
      _tw_count_280 = 0;
      _tw_count_281 = 0;
      _tw_count_282 = 0;
      _tw_count_283 = 0;
      _tw_count_284 = 0;
      _tw_count_285 = 0;
      _tw_count_286 = 0;
      _tw_count_287 = 0;
      _tw_count_288 = 0;
      _tw_count_289 = 0;
      _tw_count_290 = 0;
      _tw_count_291 = 0;
      _tw_count_292 = 0;
      _tw_count_293 = 0;
      _tw_count_294 = 0;
      _tw_count_295 = 0;
      _tw_count_296 = 0;
      _tw_count_297 = 0;
      _tw_count_298 = 0;
      _tw_count_299 = 0;
      _tw_count_300 = 0;
      _tw_count_301 = 0;
      _tw_count_302 = 0;
      _tw_count_303 = 0;
      _tw_count_304 = 0;
      _tw_count_305 = 0;
      _tw_count_306 = 0;
      _tw_count_307 = 0;
      _tw_count_308 = 0;
      _tw_count_309 = 0;
      _tw_count_310 = 0;
      _tw_count_311 = 0;
      _tw_count_312 = 0;
      _tw_count_313 = 0;
      _tw_count_314 = 0;
      _tw_count_315 = 0;
      _tw_count_316 = 0;
      _tw_count_317 = 0;
      _tw_count_318 = 0;
      _tw_count_319 = 0;
      _tw_count_320 = 0;
      _tw_count_321 = 0;
      _tw_count_322 = 0;
      _tw_count_323 = 0;
      _tw_count_324 = 0;
      _tw_count_325 = 0;
      _tw_count_326 = 0;
      _tw_count_327 = 0;
      _tw_count_328 = 0;
      _tw_count_329 = 0;
      _tw_count_330 = 0;
      _tw_count_331 = 0;
      _tw_count_332 = 0;
      _tw_count_333 = 0;
      _tw_count_334 = 0;
      _tw_count_335 = 0;
      _tw_count_336 = 0;
      _tw_count_337 = 0;
      _tw_count_338 = 0;
      _tw_count_339 = 0;
      _tw_count_340 = 0;
      _tw_count_341 = 0;
      _tw_count_342 = 0;
      _tw_count_343 = 0;
      _tw_count_344 = 0;
      _tw_count_345 = 0;
      _tw_count_346 = 0;
      _tw_count_347 = 0;
      _tw_count_348 = 0;
      _tw_count_349 = 0;
      _tw_count_350 = 0;
      _tw_count_351 = 0;
      _tw_count_352 = 0;
      _tw_count_353 = 0;
      _tw_count_354 = 0;
      _tw_count_355 = 0;
      _tw_count_356 = 0;
      _tw_count_357 = 0;
      _tw_count_358 = 0;
      _tw_count_359 = 0;
      _tw_count_360 = 0;
      _tw_count_361 = 0;
      _tw_count_362 = 0;
      _tw_count_363 = 0;
      _tw_count_364 = 0;
      _tw_count_365 = 0;
      _tw_count_366 = 0;
      _tw_count_367 = 0;
      _tw_count_368 = 0;
      _tw_count_369 = 0;
      _tw_count_370 = 0;
      _tw_count_371 = 0;
      _tw_count_372 = 0;
      _tw_count_373 = 0;
      _tw_count_374 = 0;
      _tw_count_375 = 0;
      _tw_count_376 = 0;
      _tw_count_377 = 0;
      _tw_count_378 = 0;
      _tw_count_379 = 0;
      _tw_count_380 = 0;
      _tw_count_381 = 0;
      _tw_count_382 = 0;
      _tw_count_383 = 0;
      _tw_count_384 = 0;
      _tw_count_385 = 0;
      _tw_count_386 = 0;
      _tw_count_387 = 0;
      _tw_count_388 = 0;
      _tw_count_389 = 0;
      _tw_count_390 = 0;
      _tw_count_391 = 0;
      _tw_count_392 = 0;
      _tw_count_393 = 0;
      _tw_count_394 = 0;
      _tw_count_395 = 0;
      _tw_count_396 = 0;
      _tw_count_397 = 0;
      _tw_count_398 = 0;
      _tw_count_399 = 0;
      _tw_count_400 = 0;
      _tw_count_401 = 0;
      _tw_count_402 = 0;
      _tw_count_403 = 0;
      _tw_count_404 = 0;
      _tw_count_405 = 0;
      _tw_count_406 = 0;
      _tw_count_407 = 0;
      _tw_count_408 = 0;
      _tw_count_409 = 0;
      _tw_count_410 = 0;
      _tw_count_411 = 0;
      _tw_count_412 = 0;
      _tw_count_413 = 0;
      _tw_count_414 = 0;
      _tw_count_415 = 0;
      _tw_count_416 = 0;
      _tw_count_417 = 0;
      _tw_count_418 = 0;
      _tw_count_419 = 0;
      _tw_count_420 = 0;
      _tw_count_421 = 0;
      _tw_count_422 = 0;
      _tw_count_423 = 0;
      _tw_count_424 = 0;
      _tw_count_425 = 0;
      _tw_count_426 = 0;
      _tw_count_427 = 0;
      _tw_count_428 = 0;
      _tw_count_429 = 0;
      _tw_count_430 = 0;
      _tw_count_431 = 0;
      _tw_count_432 = 0;
      _tw_count_433 = 0;
      _tw_count_434 = 0;
      _tw_count_435 = 0;
      _tw_count_436 = 0;
      _tw_count_437 = 0;
      _tw_count_438 = 0;
      _tw_count_439 = 0;
      _tw_count_440 = 0;
      _tw_count_441 = 0;
      _tw_count_442 = 0;
      _tw_count_443 = 0;
      _tw_count_444 = 0;
      _tw_count_445 = 0;
      _tw_count_446 = 0;
      _tw_count_447 = 0;
      _tw_count_448 = 0;
      _tw_count_449 = 0;
      _tw_count_450 = 0;
      _tw_count_451 = 0;
      _tw_count_452 = 0;
      _tw_count_453 = 0;
      _tw_count_454 = 0;
      _tw_count_455 = 0;
      _tw_count_456 = 0;
      _tw_count_457 = 0;
      _tw_count_458 = 0;
      _tw_count_459 = 0;
      _tw_count_460 = 0;
      _tw_count_461 = 0;
      _tw_count_462 = 0;
      _tw_count_463 = 0;
      _tw_count_464 = 0;
      _tw_count_465 = 0;
      _tw_count_466 = 0;
      _tw_count_467 = 0;
      _tw_count_468 = 0;
      _tw_count_469 = 0;
      _tw_count_470 = 0;
      _tw_count_471 = 0;
      _tw_count_472 = 0;
      _tw_count_473 = 0;
      _tw_count_474 = 0;
      _tw_count_475 = 0;
      _tw_count_476 = 0;
      _tw_count_477 = 0;
      _tw_count_478 = 0;
      _tw_count_479 = 0;
      _tw_count_480 = 0;
      _tw_count_481 = 0;
      _tw_count_482 = 0;
      _tw_count_483 = 0;
      _tw_count_484 = 0;
      _tw_count_485 = 0;
      _tw_count_486 = 0;
      _tw_count_487 = 0;
      _tw_count_488 = 0;
      _tw_count_489 = 0;
      _tw_count_490 = 0;
      _tw_count_491 = 0;
      _tw_count_492 = 0;
      _tw_count_493 = 0;
      _tw_count_494 = 0;
      _tw_count_495 = 0;
      _tw_count_496 = 0;
      _tw_count_497 = 0;
      _tw_count_498 = 0;
      _tw_count_499 = 0;
      _tw_count_500 = 0;
      _tw_count_501 = 0;
      _tw_count_502 = 0;
      _tw_count_503 = 0;
      _tw_count_504 = 0;
      _tw_count_505 = 0;
      _tw_count_506 = 0;
      _tw_count_507 = 0;
      _tw_count_508 = 0;
      _tw_count_509 = 0;
      _tw_count_510 = 0;
      _tw_count_511 = 0;
      _tw_count_512 = 0;
      _tw_count_513 = 0;
      _tw_count_514 = 0;
      _tw_count_515 = 0;
      _tw_count_516 = 0;
      _tw_count_517 = 0;
      _tw_count_518 = 0;
      _tw_count_519 = 0;
      _tw_count_520 = 0;
      _tw_count_521 = 0;
      _tw_count_522 = 0;
      _tw_count_523 = 0;
      _tw_count_524 = 0;
      _tw_count_525 = 0;
      _tw_count_526 = 0;
      _tw_count_527 = 0;
      _tw_count_528 = 0;
      _tw_count_529 = 0;
      _tw_count_530 = 0;
      _tw_count_531 = 0;
      _tw_count_532 = 0;
      _tw_count_533 = 0;
      _tw_count_534 = 0;
      _tw_count_535 = 0;
      _tw_count_536 = 0;
      _tw_count_537 = 0;
      _tw_count_538 = 0;
      _tw_count_539 = 0;
      _tw_count_540 = 0;
      _tw_count_541 = 0;
      _tw_count_542 = 0;
      _tw_count_543 = 0;
      _tw_count_544 = 0;
      _tw_count_545 = 0;
      _tw_count_546 = 0;
      _tw_count_547 = 0;
      _tw_count_548 = 0;
      _tw_count_549 = 0;
      _tw_count_550 = 0;
      _tw_count_551 = 0;
      _tw_count_552 = 0;
      _tw_count_553 = 0;
      _tw_count_554 = 0;
      _tw_count_555 = 0;
      _tw_count_556 = 0;
      _tw_count_557 = 0;
      _tw_count_558 = 0;
      _tw_count_559 = 0;
      _tw_count_560 = 0;
      _tw_count_561 = 0;
      _tw_count_562 = 0;
      _tw_count_563 = 0;
      _tw_count_564 = 0;
      _tw_count_565 = 0;
      _tw_count_566 = 0;
      _tw_count_567 = 0;
      _tw_count_568 = 0;
      _tw_count_569 = 0;
      _tw_count_570 = 0;
      _tw_count_571 = 0;
      _tw_count_572 = 0;
      _tw_count_573 = 0;
      _tw_count_574 = 0;
      _tw_count_575 = 0;
      _tw_count_576 = 0;
      _tw_count_577 = 0;
      _tw_count_578 = 0;
      _tw_count_579 = 0;
      _tw_count_580 = 0;
      _tw_count_581 = 0;
      _tw_count_582 = 0;
      _tw_count_583 = 0;
      _tw_count_584 = 0;
      _tw_count_585 = 0;
      _tw_count_586 = 0;
      _tw_count_587 = 0;
      _tw_count_588 = 0;
      _tw_count_589 = 0;
      _tw_count_590 = 0;
      _tw_count_591 = 0;
      _tw_count_592 = 0;
      _tw_count_593 = 0;
      _tw_count_594 = 0;
      _tw_count_595 = 0;
      _tw_count_596 = 0;
      _tw_count_597 = 0;
      _tw_count_598 = 0;
      _tw_count_599 = 0;
      _tw_count_600 = 0;
      _tw_count_601 = 0;
      _tw_count_602 = 0;
      _tw_count_603 = 0;
      _tw_count_604 = 0;
      _tw_count_605 = 0;
      _tw_count_606 = 0;
      _tw_count_607 = 0;
    end

    // reset fall at 100 ns
    @(timer(100000000e-15 * time_scale, 10000000000e-15 * time_scale)) begin
      if ((cycles == 0) || (_tw_count_0 < cycles)) begin
        _tw_level_0 = 0;
        if (cycles > 0) _tw_count_0 = _tw_count_0 + 1;
      end
    end

    // reset rise at 10000 ns (next macroperiod)
    @(timer(10000000000e-15 * time_scale, 10000000000e-15 * time_scale)) begin
      if ((cycles == 0) || (_tw_count_1 < cycles)) begin
        _tw_level_0 = 1;
        if (cycles > 0) _tw_count_1 = _tw_count_1 + 1;
      end
    end

    // clk rise at 200 ns
    @(timer(200000000e-15 * time_scale, 10000000000e-15 * time_scale)) begin
      if ((cycles == 0) || (_tw_count_2 < cycles)) begin
        _tw_level_1 = 1;
        if (cycles > 0) _tw_count_2 = _tw_count_2 + 1;
      end
    end

    // clk fall at 220 ns
    @(timer(220000000e-15 * time_scale, 10000000000e-15 * time_scale)) begin
      if ((cycles == 0) || (_tw_count_3 < cycles)) begin
        _tw_level_1 = 0;
        if (cycles > 0) _tw_count_3 = _tw_count_3 + 1;
      end
    end

    // clk rise at 250 ns
    @(timer(250000000e-15 * time_scale, 10000000000e-15 * time_scale)) begin
      if ((cycles == 0) || (_tw_count_4 < cycles)) begin
        _tw_level_1 = 1;
        if (cycles > 0) _tw_count_4 = _tw_count_4 + 1;
      end
    end

    // clk fall at 270 ns
    @(timer(270000000e-15 * time_scale, 10000000000e-15 * time_scale)) begin
      if ((cycles == 0) || (_tw_count_5 < cycles)) begin
        _tw_level_1 = 0;
        if (cycles > 0) _tw_count_5 = _tw_count_5 + 1;
      end
    end

    // clk rise at 300 ns
    @(timer(300000000e-15 * time_scale, 10000000000e-15 * time_scale)) begin
      if ((cycles == 0) || (_tw_count_6 < cycles)) begin
        _tw_level_1 = 1;
        if (cycles > 0) _tw_count_6 = _tw_count_6 + 1;
      end
    end

    // clk fall at 320 ns
    @(timer(320000000e-15 * time_scale, 10000000000e-15 * time_scale)) begin
      if ((cycles == 0) || (_tw_count_7 < cycles)) begin
        _tw_level_1 = 0;
        if (cycles > 0) _tw_count_7 = _tw_count_7 + 1;
      end
    end

    // clk rise at 350 ns
    @(timer(350000000e-15 * time_scale, 10000000000e-15 * time_scale)) begin
      if ((cycles == 0) || (_tw_count_8 < cycles)) begin
        _tw_level_1 = 1;
        if (cycles > 0) _tw_count_8 = _tw_count_8 + 1;
      end
    end

    // clk fall at 370 ns
    @(timer(370000000e-15 * time_scale, 10000000000e-15 * time_scale)) begin
      if ((cycles == 0) || (_tw_count_9 < cycles)) begin
        _tw_level_1 = 0;
        if (cycles > 0) _tw_count_9 = _tw_count_9 + 1;
      end
    end

    // clk rise at 400 ns
    @(timer(400000000e-15 * time_scale, 10000000000e-15 * time_scale)) begin
      if ((cycles == 0) || (_tw_count_10 < cycles)) begin
        _tw_level_1 = 1;
        if (cycles > 0) _tw_count_10 = _tw_count_10 + 1;
      end
    end

    // clk fall at 420 ns
    @(timer(420000000e-15 * time_scale, 10000000000e-15 * time_scale)) begin
      if ((cycles == 0) || (_tw_count_11 < cycles)) begin
        _tw_level_1 = 0;
        if (cycles > 0) _tw_count_11 = _tw_count_11 + 1;
      end
    end

    // clk rise at 450 ns
    @(timer(450000000e-15 * time_scale, 10000000000e-15 * time_scale)) begin
      if ((cycles == 0) || (_tw_count_12 < cycles)) begin
        _tw_level_1 = 1;
        if (cycles > 0) _tw_count_12 = _tw_count_12 + 1;
      end
    end

    // clk fall at 470 ns
    @(timer(470000000e-15 * time_scale, 10000000000e-15 * time_scale)) begin
      if ((cycles == 0) || (_tw_count_13 < cycles)) begin
        _tw_level_1 = 0;
        if (cycles > 0) _tw_count_13 = _tw_count_13 + 1;
      end
    end

    // clk rise at 500 ns
    @(timer(500000000e-15 * time_scale, 10000000000e-15 * time_scale)) begin
      if ((cycles == 0) || (_tw_count_14 < cycles)) begin
        _tw_level_1 = 1;
        if (cycles > 0) _tw_count_14 = _tw_count_14 + 1;
      end
    end

    // clk fall at 520 ns
    @(timer(520000000e-15 * time_scale, 10000000000e-15 * time_scale)) begin
      if ((cycles == 0) || (_tw_count_15 < cycles)) begin
        _tw_level_1 = 0;
        if (cycles > 0) _tw_count_15 = _tw_count_15 + 1;
      end
    end

    // clk rise at 550 ns
    @(timer(550000000e-15 * time_scale, 10000000000e-15 * time_scale)) begin
      if ((cycles == 0) || (_tw_count_16 < cycles)) begin
        _tw_level_1 = 1;
        if (cycles > 0) _tw_count_16 = _tw_count_16 + 1;
      end
    end

    // clk fall at 570 ns
    @(timer(570000000e-15 * time_scale, 10000000000e-15 * time_scale)) begin
      if ((cycles == 0) || (_tw_count_17 < cycles)) begin
        _tw_level_1 = 0;
        if (cycles > 0) _tw_count_17 = _tw_count_17 + 1;
      end
    end

    // clk rise at 600 ns
    @(timer(600000000e-15 * time_scale, 10000000000e-15 * time_scale)) begin
      if ((cycles == 0) || (_tw_count_18 < cycles)) begin
        _tw_level_1 = 1;
        if (cycles > 0) _tw_count_18 = _tw_count_18 + 1;
      end
    end

    // clk fall at 620 ns
    @(timer(620000000e-15 * time_scale, 10000000000e-15 * time_scale)) begin
      if ((cycles == 0) || (_tw_count_19 < cycles)) begin
        _tw_level_1 = 0;
        if (cycles > 0) _tw_count_19 = _tw_count_19 + 1;
      end
    end

    // clk rise at 650 ns
    @(timer(650000000e-15 * time_scale, 10000000000e-15 * time_scale)) begin
      if ((cycles == 0) || (_tw_count_20 < cycles)) begin
        _tw_level_1 = 1;
        if (cycles > 0) _tw_count_20 = _tw_count_20 + 1;
      end
    end

    // clk fall at 670 ns
    @(timer(670000000e-15 * time_scale, 10000000000e-15 * time_scale)) begin
      if ((cycles == 0) || (_tw_count_21 < cycles)) begin
        _tw_level_1 = 0;
        if (cycles > 0) _tw_count_21 = _tw_count_21 + 1;
      end
    end

    // clk rise at 700 ns
    @(timer(700000000e-15 * time_scale, 10000000000e-15 * time_scale)) begin
      if ((cycles == 0) || (_tw_count_22 < cycles)) begin
        _tw_level_1 = 1;
        if (cycles > 0) _tw_count_22 = _tw_count_22 + 1;
      end
    end

    // clk fall at 720 ns
    @(timer(720000000e-15 * time_scale, 10000000000e-15 * time_scale)) begin
      if ((cycles == 0) || (_tw_count_23 < cycles)) begin
        _tw_level_1 = 0;
        if (cycles > 0) _tw_count_23 = _tw_count_23 + 1;
      end
    end

    // clk rise at 750 ns
    @(timer(750000000e-15 * time_scale, 10000000000e-15 * time_scale)) begin
      if ((cycles == 0) || (_tw_count_24 < cycles)) begin
        _tw_level_1 = 1;
        if (cycles > 0) _tw_count_24 = _tw_count_24 + 1;
      end
    end

    // clk fall at 770 ns
    @(timer(770000000e-15 * time_scale, 10000000000e-15 * time_scale)) begin
      if ((cycles == 0) || (_tw_count_25 < cycles)) begin
        _tw_level_1 = 0;
        if (cycles > 0) _tw_count_25 = _tw_count_25 + 1;
      end
    end

    // clk rise at 800 ns
    @(timer(800000000e-15 * time_scale, 10000000000e-15 * time_scale)) begin
      if ((cycles == 0) || (_tw_count_26 < cycles)) begin
        _tw_level_1 = 1;
        if (cycles > 0) _tw_count_26 = _tw_count_26 + 1;
      end
    end

    // clk fall at 820 ns
    @(timer(820000000e-15 * time_scale, 10000000000e-15 * time_scale)) begin
      if ((cycles == 0) || (_tw_count_27 < cycles)) begin
        _tw_level_1 = 0;
        if (cycles > 0) _tw_count_27 = _tw_count_27 + 1;
      end
    end

    // clk rise at 850 ns
    @(timer(850000000e-15 * time_scale, 10000000000e-15 * time_scale)) begin
      if ((cycles == 0) || (_tw_count_28 < cycles)) begin
        _tw_level_1 = 1;
        if (cycles > 0) _tw_count_28 = _tw_count_28 + 1;
      end
    end

    // clk fall at 870 ns
    @(timer(870000000e-15 * time_scale, 10000000000e-15 * time_scale)) begin
      if ((cycles == 0) || (_tw_count_29 < cycles)) begin
        _tw_level_1 = 0;
        if (cycles > 0) _tw_count_29 = _tw_count_29 + 1;
      end
    end

    // clk rise at 900 ns
    @(timer(900000000e-15 * time_scale, 10000000000e-15 * time_scale)) begin
      if ((cycles == 0) || (_tw_count_30 < cycles)) begin
        _tw_level_1 = 1;
        if (cycles > 0) _tw_count_30 = _tw_count_30 + 1;
      end
    end

    // clk fall at 920 ns
    @(timer(920000000e-15 * time_scale, 10000000000e-15 * time_scale)) begin
      if ((cycles == 0) || (_tw_count_31 < cycles)) begin
        _tw_level_1 = 0;
        if (cycles > 0) _tw_count_31 = _tw_count_31 + 1;
      end
    end

    // clk rise at 950 ns
    @(timer(950000000e-15 * time_scale, 10000000000e-15 * time_scale)) begin
      if ((cycles == 0) || (_tw_count_32 < cycles)) begin
        _tw_level_1 = 1;
        if (cycles > 0) _tw_count_32 = _tw_count_32 + 1;
      end
    end

    // clk fall at 970 ns
    @(timer(970000000e-15 * time_scale, 10000000000e-15 * time_scale)) begin
      if ((cycles == 0) || (_tw_count_33 < cycles)) begin
        _tw_level_1 = 0;
        if (cycles > 0) _tw_count_33 = _tw_count_33 + 1;
      end
    end

    // clk rise at 1000 ns
    @(timer(1000000000e-15 * time_scale, 10000000000e-15 * time_scale)) begin
      if ((cycles == 0) || (_tw_count_34 < cycles)) begin
        _tw_level_1 = 1;
        if (cycles > 0) _tw_count_34 = _tw_count_34 + 1;
      end
    end

    // clk fall at 1020 ns
    @(timer(1020000000e-15 * time_scale, 10000000000e-15 * time_scale)) begin
      if ((cycles == 0) || (_tw_count_35 < cycles)) begin
        _tw_level_1 = 0;
        if (cycles > 0) _tw_count_35 = _tw_count_35 + 1;
      end
    end

    // clk rise at 1050 ns
    @(timer(1050000000e-15 * time_scale, 10000000000e-15 * time_scale)) begin
      if ((cycles == 0) || (_tw_count_36 < cycles)) begin
        _tw_level_1 = 1;
        if (cycles > 0) _tw_count_36 = _tw_count_36 + 1;
      end
    end

    // clk fall at 1070 ns
    @(timer(1070000000e-15 * time_scale, 10000000000e-15 * time_scale)) begin
      if ((cycles == 0) || (_tw_count_37 < cycles)) begin
        _tw_level_1 = 0;
        if (cycles > 0) _tw_count_37 = _tw_count_37 + 1;
      end
    end

    // clk rise at 1100 ns
    @(timer(1100000000e-15 * time_scale, 10000000000e-15 * time_scale)) begin
      if ((cycles == 0) || (_tw_count_38 < cycles)) begin
        _tw_level_1 = 1;
        if (cycles > 0) _tw_count_38 = _tw_count_38 + 1;
      end
    end

    // clk fall at 1120 ns
    @(timer(1120000000e-15 * time_scale, 10000000000e-15 * time_scale)) begin
      if ((cycles == 0) || (_tw_count_39 < cycles)) begin
        _tw_level_1 = 0;
        if (cycles > 0) _tw_count_39 = _tw_count_39 + 1;
      end
    end

    // clk rise at 1150 ns
    @(timer(1150000000e-15 * time_scale, 10000000000e-15 * time_scale)) begin
      if ((cycles == 0) || (_tw_count_40 < cycles)) begin
        _tw_level_1 = 1;
        if (cycles > 0) _tw_count_40 = _tw_count_40 + 1;
      end
    end

    // clk fall at 1170 ns
    @(timer(1170000000e-15 * time_scale, 10000000000e-15 * time_scale)) begin
      if ((cycles == 0) || (_tw_count_41 < cycles)) begin
        _tw_level_1 = 0;
        if (cycles > 0) _tw_count_41 = _tw_count_41 + 1;
      end
    end

    // clk rise at 1200 ns
    @(timer(1200000000e-15 * time_scale, 10000000000e-15 * time_scale)) begin
      if ((cycles == 0) || (_tw_count_42 < cycles)) begin
        _tw_level_1 = 1;
        if (cycles > 0) _tw_count_42 = _tw_count_42 + 1;
      end
    end

    // clk fall at 1220 ns
    @(timer(1220000000e-15 * time_scale, 10000000000e-15 * time_scale)) begin
      if ((cycles == 0) || (_tw_count_43 < cycles)) begin
        _tw_level_1 = 0;
        if (cycles > 0) _tw_count_43 = _tw_count_43 + 1;
      end
    end

    // clk rise at 1250 ns
    @(timer(1250000000e-15 * time_scale, 10000000000e-15 * time_scale)) begin
      if ((cycles == 0) || (_tw_count_44 < cycles)) begin
        _tw_level_1 = 1;
        if (cycles > 0) _tw_count_44 = _tw_count_44 + 1;
      end
    end

    // clk fall at 1270 ns
    @(timer(1270000000e-15 * time_scale, 10000000000e-15 * time_scale)) begin
      if ((cycles == 0) || (_tw_count_45 < cycles)) begin
        _tw_level_1 = 0;
        if (cycles > 0) _tw_count_45 = _tw_count_45 + 1;
      end
    end

    // clk rise at 1300 ns
    @(timer(1300000000e-15 * time_scale, 10000000000e-15 * time_scale)) begin
      if ((cycles == 0) || (_tw_count_46 < cycles)) begin
        _tw_level_1 = 1;
        if (cycles > 0) _tw_count_46 = _tw_count_46 + 1;
      end
    end

    // clk fall at 1320 ns
    @(timer(1320000000e-15 * time_scale, 10000000000e-15 * time_scale)) begin
      if ((cycles == 0) || (_tw_count_47 < cycles)) begin
        _tw_level_1 = 0;
        if (cycles > 0) _tw_count_47 = _tw_count_47 + 1;
      end
    end

    // clk rise at 1350 ns
    @(timer(1350000000e-15 * time_scale, 10000000000e-15 * time_scale)) begin
      if ((cycles == 0) || (_tw_count_48 < cycles)) begin
        _tw_level_1 = 1;
        if (cycles > 0) _tw_count_48 = _tw_count_48 + 1;
      end
    end

    // clk fall at 1370 ns
    @(timer(1370000000e-15 * time_scale, 10000000000e-15 * time_scale)) begin
      if ((cycles == 0) || (_tw_count_49 < cycles)) begin
        _tw_level_1 = 0;
        if (cycles > 0) _tw_count_49 = _tw_count_49 + 1;
      end
    end

    // clk rise at 1400 ns
    @(timer(1400000000e-15 * time_scale, 10000000000e-15 * time_scale)) begin
      if ((cycles == 0) || (_tw_count_50 < cycles)) begin
        _tw_level_1 = 1;
        if (cycles > 0) _tw_count_50 = _tw_count_50 + 1;
      end
    end

    // clk fall at 1420 ns
    @(timer(1420000000e-15 * time_scale, 10000000000e-15 * time_scale)) begin
      if ((cycles == 0) || (_tw_count_51 < cycles)) begin
        _tw_level_1 = 0;
        if (cycles > 0) _tw_count_51 = _tw_count_51 + 1;
      end
    end

    // clk rise at 1450 ns
    @(timer(1450000000e-15 * time_scale, 10000000000e-15 * time_scale)) begin
      if ((cycles == 0) || (_tw_count_52 < cycles)) begin
        _tw_level_1 = 1;
        if (cycles > 0) _tw_count_52 = _tw_count_52 + 1;
      end
    end

    // clk fall at 1470 ns
    @(timer(1470000000e-15 * time_scale, 10000000000e-15 * time_scale)) begin
      if ((cycles == 0) || (_tw_count_53 < cycles)) begin
        _tw_level_1 = 0;
        if (cycles > 0) _tw_count_53 = _tw_count_53 + 1;
      end
    end

    // clk rise at 1500 ns
    @(timer(1500000000e-15 * time_scale, 10000000000e-15 * time_scale)) begin
      if ((cycles == 0) || (_tw_count_54 < cycles)) begin
        _tw_level_1 = 1;
        if (cycles > 0) _tw_count_54 = _tw_count_54 + 1;
      end
    end

    // clk fall at 1520 ns
    @(timer(1520000000e-15 * time_scale, 10000000000e-15 * time_scale)) begin
      if ((cycles == 0) || (_tw_count_55 < cycles)) begin
        _tw_level_1 = 0;
        if (cycles > 0) _tw_count_55 = _tw_count_55 + 1;
      end
    end

    // clk rise at 1550 ns
    @(timer(1550000000e-15 * time_scale, 10000000000e-15 * time_scale)) begin
      if ((cycles == 0) || (_tw_count_56 < cycles)) begin
        _tw_level_1 = 1;
        if (cycles > 0) _tw_count_56 = _tw_count_56 + 1;
      end
    end

    // clk fall at 1570 ns
    @(timer(1570000000e-15 * time_scale, 10000000000e-15 * time_scale)) begin
      if ((cycles == 0) || (_tw_count_57 < cycles)) begin
        _tw_level_1 = 0;
        if (cycles > 0) _tw_count_57 = _tw_count_57 + 1;
      end
    end

    // clk rise at 1600 ns
    @(timer(1600000000e-15 * time_scale, 10000000000e-15 * time_scale)) begin
      if ((cycles == 0) || (_tw_count_58 < cycles)) begin
        _tw_level_1 = 1;
        if (cycles > 0) _tw_count_58 = _tw_count_58 + 1;
      end
    end

    // clk fall at 1620 ns
    @(timer(1620000000e-15 * time_scale, 10000000000e-15 * time_scale)) begin
      if ((cycles == 0) || (_tw_count_59 < cycles)) begin
        _tw_level_1 = 0;
        if (cycles > 0) _tw_count_59 = _tw_count_59 + 1;
      end
    end

    // clk rise at 1650 ns
    @(timer(1650000000e-15 * time_scale, 10000000000e-15 * time_scale)) begin
      if ((cycles == 0) || (_tw_count_60 < cycles)) begin
        _tw_level_1 = 1;
        if (cycles > 0) _tw_count_60 = _tw_count_60 + 1;
      end
    end

    // clk fall at 1670 ns
    @(timer(1670000000e-15 * time_scale, 10000000000e-15 * time_scale)) begin
      if ((cycles == 0) || (_tw_count_61 < cycles)) begin
        _tw_level_1 = 0;
        if (cycles > 0) _tw_count_61 = _tw_count_61 + 1;
      end
    end

    // clk rise at 1700 ns
    @(timer(1700000000e-15 * time_scale, 10000000000e-15 * time_scale)) begin
      if ((cycles == 0) || (_tw_count_62 < cycles)) begin
        _tw_level_1 = 1;
        if (cycles > 0) _tw_count_62 = _tw_count_62 + 1;
      end
    end

    // clk fall at 1720 ns
    @(timer(1720000000e-15 * time_scale, 10000000000e-15 * time_scale)) begin
      if ((cycles == 0) || (_tw_count_63 < cycles)) begin
        _tw_level_1 = 0;
        if (cycles > 0) _tw_count_63 = _tw_count_63 + 1;
      end
    end

    // clk rise at 1750 ns
    @(timer(1750000000e-15 * time_scale, 10000000000e-15 * time_scale)) begin
      if ((cycles == 0) || (_tw_count_64 < cycles)) begin
        _tw_level_1 = 1;
        if (cycles > 0) _tw_count_64 = _tw_count_64 + 1;
      end
    end

    // clk fall at 1770 ns
    @(timer(1770000000e-15 * time_scale, 10000000000e-15 * time_scale)) begin
      if ((cycles == 0) || (_tw_count_65 < cycles)) begin
        _tw_level_1 = 0;
        if (cycles > 0) _tw_count_65 = _tw_count_65 + 1;
      end
    end

    // clk rise at 1800 ns
    @(timer(1800000000e-15 * time_scale, 10000000000e-15 * time_scale)) begin
      if ((cycles == 0) || (_tw_count_66 < cycles)) begin
        _tw_level_1 = 1;
        if (cycles > 0) _tw_count_66 = _tw_count_66 + 1;
      end
    end

    // clk fall at 1820 ns
    @(timer(1820000000e-15 * time_scale, 10000000000e-15 * time_scale)) begin
      if ((cycles == 0) || (_tw_count_67 < cycles)) begin
        _tw_level_1 = 0;
        if (cycles > 0) _tw_count_67 = _tw_count_67 + 1;
      end
    end

    // clk rise at 1850 ns
    @(timer(1850000000e-15 * time_scale, 10000000000e-15 * time_scale)) begin
      if ((cycles == 0) || (_tw_count_68 < cycles)) begin
        _tw_level_1 = 1;
        if (cycles > 0) _tw_count_68 = _tw_count_68 + 1;
      end
    end

    // clk fall at 1870 ns
    @(timer(1870000000e-15 * time_scale, 10000000000e-15 * time_scale)) begin
      if ((cycles == 0) || (_tw_count_69 < cycles)) begin
        _tw_level_1 = 0;
        if (cycles > 0) _tw_count_69 = _tw_count_69 + 1;
      end
    end

    // clk rise at 1900 ns
    @(timer(1900000000e-15 * time_scale, 10000000000e-15 * time_scale)) begin
      if ((cycles == 0) || (_tw_count_70 < cycles)) begin
        _tw_level_1 = 1;
        if (cycles > 0) _tw_count_70 = _tw_count_70 + 1;
      end
    end

    // clk fall at 1920 ns
    @(timer(1920000000e-15 * time_scale, 10000000000e-15 * time_scale)) begin
      if ((cycles == 0) || (_tw_count_71 < cycles)) begin
        _tw_level_1 = 0;
        if (cycles > 0) _tw_count_71 = _tw_count_71 + 1;
      end
    end

    // clk rise at 1950 ns
    @(timer(1950000000e-15 * time_scale, 10000000000e-15 * time_scale)) begin
      if ((cycles == 0) || (_tw_count_72 < cycles)) begin
        _tw_level_1 = 1;
        if (cycles > 0) _tw_count_72 = _tw_count_72 + 1;
      end
    end

    // clk fall at 1970 ns
    @(timer(1970000000e-15 * time_scale, 10000000000e-15 * time_scale)) begin
      if ((cycles == 0) || (_tw_count_73 < cycles)) begin
        _tw_level_1 = 0;
        if (cycles > 0) _tw_count_73 = _tw_count_73 + 1;
      end
    end

    // clk rise at 2000 ns
    @(timer(2000000000e-15 * time_scale, 10000000000e-15 * time_scale)) begin
      if ((cycles == 0) || (_tw_count_74 < cycles)) begin
        _tw_level_1 = 1;
        if (cycles > 0) _tw_count_74 = _tw_count_74 + 1;
      end
    end

    // clk fall at 2020 ns
    @(timer(2020000000e-15 * time_scale, 10000000000e-15 * time_scale)) begin
      if ((cycles == 0) || (_tw_count_75 < cycles)) begin
        _tw_level_1 = 0;
        if (cycles > 0) _tw_count_75 = _tw_count_75 + 1;
      end
    end

    // clk rise at 2050 ns
    @(timer(2050000000e-15 * time_scale, 10000000000e-15 * time_scale)) begin
      if ((cycles == 0) || (_tw_count_76 < cycles)) begin
        _tw_level_1 = 1;
        if (cycles > 0) _tw_count_76 = _tw_count_76 + 1;
      end
    end

    // clk fall at 2070 ns
    @(timer(2070000000e-15 * time_scale, 10000000000e-15 * time_scale)) begin
      if ((cycles == 0) || (_tw_count_77 < cycles)) begin
        _tw_level_1 = 0;
        if (cycles > 0) _tw_count_77 = _tw_count_77 + 1;
      end
    end

    // clk rise at 2100 ns
    @(timer(2100000000e-15 * time_scale, 10000000000e-15 * time_scale)) begin
      if ((cycles == 0) || (_tw_count_78 < cycles)) begin
        _tw_level_1 = 1;
        if (cycles > 0) _tw_count_78 = _tw_count_78 + 1;
      end
    end

    // clk fall at 2120 ns
    @(timer(2120000000e-15 * time_scale, 10000000000e-15 * time_scale)) begin
      if ((cycles == 0) || (_tw_count_79 < cycles)) begin
        _tw_level_1 = 0;
        if (cycles > 0) _tw_count_79 = _tw_count_79 + 1;
      end
    end

    // clk rise at 2150 ns
    @(timer(2150000000e-15 * time_scale, 10000000000e-15 * time_scale)) begin
      if ((cycles == 0) || (_tw_count_80 < cycles)) begin
        _tw_level_1 = 1;
        if (cycles > 0) _tw_count_80 = _tw_count_80 + 1;
      end
    end

    // clk fall at 2170 ns
    @(timer(2170000000e-15 * time_scale, 10000000000e-15 * time_scale)) begin
      if ((cycles == 0) || (_tw_count_81 < cycles)) begin
        _tw_level_1 = 0;
        if (cycles > 0) _tw_count_81 = _tw_count_81 + 1;
      end
    end

    // clk rise at 2200 ns
    @(timer(2200000000e-15 * time_scale, 10000000000e-15 * time_scale)) begin
      if ((cycles == 0) || (_tw_count_82 < cycles)) begin
        _tw_level_1 = 1;
        if (cycles > 0) _tw_count_82 = _tw_count_82 + 1;
      end
    end

    // clk fall at 2220 ns
    @(timer(2220000000e-15 * time_scale, 10000000000e-15 * time_scale)) begin
      if ((cycles == 0) || (_tw_count_83 < cycles)) begin
        _tw_level_1 = 0;
        if (cycles > 0) _tw_count_83 = _tw_count_83 + 1;
      end
    end

    // clk rise at 2250 ns
    @(timer(2250000000e-15 * time_scale, 10000000000e-15 * time_scale)) begin
      if ((cycles == 0) || (_tw_count_84 < cycles)) begin
        _tw_level_1 = 1;
        if (cycles > 0) _tw_count_84 = _tw_count_84 + 1;
      end
    end

    // clk fall at 2270 ns
    @(timer(2270000000e-15 * time_scale, 10000000000e-15 * time_scale)) begin
      if ((cycles == 0) || (_tw_count_85 < cycles)) begin
        _tw_level_1 = 0;
        if (cycles > 0) _tw_count_85 = _tw_count_85 + 1;
      end
    end

    // clk rise at 2300 ns
    @(timer(2300000000e-15 * time_scale, 10000000000e-15 * time_scale)) begin
      if ((cycles == 0) || (_tw_count_86 < cycles)) begin
        _tw_level_1 = 1;
        if (cycles > 0) _tw_count_86 = _tw_count_86 + 1;
      end
    end

    // clk fall at 2320 ns
    @(timer(2320000000e-15 * time_scale, 10000000000e-15 * time_scale)) begin
      if ((cycles == 0) || (_tw_count_87 < cycles)) begin
        _tw_level_1 = 0;
        if (cycles > 0) _tw_count_87 = _tw_count_87 + 1;
      end
    end

    // clk rise at 2350 ns
    @(timer(2350000000e-15 * time_scale, 10000000000e-15 * time_scale)) begin
      if ((cycles == 0) || (_tw_count_88 < cycles)) begin
        _tw_level_1 = 1;
        if (cycles > 0) _tw_count_88 = _tw_count_88 + 1;
      end
    end

    // clk fall at 2370 ns
    @(timer(2370000000e-15 * time_scale, 10000000000e-15 * time_scale)) begin
      if ((cycles == 0) || (_tw_count_89 < cycles)) begin
        _tw_level_1 = 0;
        if (cycles > 0) _tw_count_89 = _tw_count_89 + 1;
      end
    end

    // clk rise at 2400 ns
    @(timer(2400000000e-15 * time_scale, 10000000000e-15 * time_scale)) begin
      if ((cycles == 0) || (_tw_count_90 < cycles)) begin
        _tw_level_1 = 1;
        if (cycles > 0) _tw_count_90 = _tw_count_90 + 1;
      end
    end

    // clk fall at 2420 ns
    @(timer(2420000000e-15 * time_scale, 10000000000e-15 * time_scale)) begin
      if ((cycles == 0) || (_tw_count_91 < cycles)) begin
        _tw_level_1 = 0;
        if (cycles > 0) _tw_count_91 = _tw_count_91 + 1;
      end
    end

    // clk rise at 2450 ns
    @(timer(2450000000e-15 * time_scale, 10000000000e-15 * time_scale)) begin
      if ((cycles == 0) || (_tw_count_92 < cycles)) begin
        _tw_level_1 = 1;
        if (cycles > 0) _tw_count_92 = _tw_count_92 + 1;
      end
    end

    // clk fall at 2470 ns
    @(timer(2470000000e-15 * time_scale, 10000000000e-15 * time_scale)) begin
      if ((cycles == 0) || (_tw_count_93 < cycles)) begin
        _tw_level_1 = 0;
        if (cycles > 0) _tw_count_93 = _tw_count_93 + 1;
      end
    end

    // clk rise at 2500 ns
    @(timer(2500000000e-15 * time_scale, 10000000000e-15 * time_scale)) begin
      if ((cycles == 0) || (_tw_count_94 < cycles)) begin
        _tw_level_1 = 1;
        if (cycles > 0) _tw_count_94 = _tw_count_94 + 1;
      end
    end

    // clk fall at 2520 ns
    @(timer(2520000000e-15 * time_scale, 10000000000e-15 * time_scale)) begin
      if ((cycles == 0) || (_tw_count_95 < cycles)) begin
        _tw_level_1 = 0;
        if (cycles > 0) _tw_count_95 = _tw_count_95 + 1;
      end
    end

    // clk rise at 2550 ns
    @(timer(2550000000e-15 * time_scale, 10000000000e-15 * time_scale)) begin
      if ((cycles == 0) || (_tw_count_96 < cycles)) begin
        _tw_level_1 = 1;
        if (cycles > 0) _tw_count_96 = _tw_count_96 + 1;
      end
    end

    // clk fall at 2570 ns
    @(timer(2570000000e-15 * time_scale, 10000000000e-15 * time_scale)) begin
      if ((cycles == 0) || (_tw_count_97 < cycles)) begin
        _tw_level_1 = 0;
        if (cycles > 0) _tw_count_97 = _tw_count_97 + 1;
      end
    end

    // clk rise at 2600 ns
    @(timer(2600000000e-15 * time_scale, 10000000000e-15 * time_scale)) begin
      if ((cycles == 0) || (_tw_count_98 < cycles)) begin
        _tw_level_1 = 1;
        if (cycles > 0) _tw_count_98 = _tw_count_98 + 1;
      end
    end

    // clk fall at 2620 ns
    @(timer(2620000000e-15 * time_scale, 10000000000e-15 * time_scale)) begin
      if ((cycles == 0) || (_tw_count_99 < cycles)) begin
        _tw_level_1 = 0;
        if (cycles > 0) _tw_count_99 = _tw_count_99 + 1;
      end
    end

    // clk rise at 2650 ns
    @(timer(2650000000e-15 * time_scale, 10000000000e-15 * time_scale)) begin
      if ((cycles == 0) || (_tw_count_100 < cycles)) begin
        _tw_level_1 = 1;
        if (cycles > 0) _tw_count_100 = _tw_count_100 + 1;
      end
    end

    // clk fall at 2670 ns
    @(timer(2670000000e-15 * time_scale, 10000000000e-15 * time_scale)) begin
      if ((cycles == 0) || (_tw_count_101 < cycles)) begin
        _tw_level_1 = 0;
        if (cycles > 0) _tw_count_101 = _tw_count_101 + 1;
      end
    end

    // clk rise at 2700 ns
    @(timer(2700000000e-15 * time_scale, 10000000000e-15 * time_scale)) begin
      if ((cycles == 0) || (_tw_count_102 < cycles)) begin
        _tw_level_1 = 1;
        if (cycles > 0) _tw_count_102 = _tw_count_102 + 1;
      end
    end

    // clk fall at 2720 ns
    @(timer(2720000000e-15 * time_scale, 10000000000e-15 * time_scale)) begin
      if ((cycles == 0) || (_tw_count_103 < cycles)) begin
        _tw_level_1 = 0;
        if (cycles > 0) _tw_count_103 = _tw_count_103 + 1;
      end
    end

    // clk rise at 2750 ns
    @(timer(2750000000e-15 * time_scale, 10000000000e-15 * time_scale)) begin
      if ((cycles == 0) || (_tw_count_104 < cycles)) begin
        _tw_level_1 = 1;
        if (cycles > 0) _tw_count_104 = _tw_count_104 + 1;
      end
    end

    // clk fall at 2770 ns
    @(timer(2770000000e-15 * time_scale, 10000000000e-15 * time_scale)) begin
      if ((cycles == 0) || (_tw_count_105 < cycles)) begin
        _tw_level_1 = 0;
        if (cycles > 0) _tw_count_105 = _tw_count_105 + 1;
      end
    end

    // clk rise at 2800 ns
    @(timer(2800000000e-15 * time_scale, 10000000000e-15 * time_scale)) begin
      if ((cycles == 0) || (_tw_count_106 < cycles)) begin
        _tw_level_1 = 1;
        if (cycles > 0) _tw_count_106 = _tw_count_106 + 1;
      end
    end

    // clk fall at 2820 ns
    @(timer(2820000000e-15 * time_scale, 10000000000e-15 * time_scale)) begin
      if ((cycles == 0) || (_tw_count_107 < cycles)) begin
        _tw_level_1 = 0;
        if (cycles > 0) _tw_count_107 = _tw_count_107 + 1;
      end
    end

    // clk rise at 2850 ns
    @(timer(2850000000e-15 * time_scale, 10000000000e-15 * time_scale)) begin
      if ((cycles == 0) || (_tw_count_108 < cycles)) begin
        _tw_level_1 = 1;
        if (cycles > 0) _tw_count_108 = _tw_count_108 + 1;
      end
    end

    // clk fall at 2870 ns
    @(timer(2870000000e-15 * time_scale, 10000000000e-15 * time_scale)) begin
      if ((cycles == 0) || (_tw_count_109 < cycles)) begin
        _tw_level_1 = 0;
        if (cycles > 0) _tw_count_109 = _tw_count_109 + 1;
      end
    end

    // clk rise at 2900 ns
    @(timer(2900000000e-15 * time_scale, 10000000000e-15 * time_scale)) begin
      if ((cycles == 0) || (_tw_count_110 < cycles)) begin
        _tw_level_1 = 1;
        if (cycles > 0) _tw_count_110 = _tw_count_110 + 1;
      end
    end

    // clk fall at 2920 ns
    @(timer(2920000000e-15 * time_scale, 10000000000e-15 * time_scale)) begin
      if ((cycles == 0) || (_tw_count_111 < cycles)) begin
        _tw_level_1 = 0;
        if (cycles > 0) _tw_count_111 = _tw_count_111 + 1;
      end
    end

    // clk rise at 2950 ns
    @(timer(2950000000e-15 * time_scale, 10000000000e-15 * time_scale)) begin
      if ((cycles == 0) || (_tw_count_112 < cycles)) begin
        _tw_level_1 = 1;
        if (cycles > 0) _tw_count_112 = _tw_count_112 + 1;
      end
    end

    // clk fall at 2970 ns
    @(timer(2970000000e-15 * time_scale, 10000000000e-15 * time_scale)) begin
      if ((cycles == 0) || (_tw_count_113 < cycles)) begin
        _tw_level_1 = 0;
        if (cycles > 0) _tw_count_113 = _tw_count_113 + 1;
      end
    end

    // clk rise at 3000 ns
    @(timer(3000000000e-15 * time_scale, 10000000000e-15 * time_scale)) begin
      if ((cycles == 0) || (_tw_count_114 < cycles)) begin
        _tw_level_1 = 1;
        if (cycles > 0) _tw_count_114 = _tw_count_114 + 1;
      end
    end

    // clk fall at 3020 ns
    @(timer(3020000000e-15 * time_scale, 10000000000e-15 * time_scale)) begin
      if ((cycles == 0) || (_tw_count_115 < cycles)) begin
        _tw_level_1 = 0;
        if (cycles > 0) _tw_count_115 = _tw_count_115 + 1;
      end
    end

    // clk rise at 3050 ns
    @(timer(3050000000e-15 * time_scale, 10000000000e-15 * time_scale)) begin
      if ((cycles == 0) || (_tw_count_116 < cycles)) begin
        _tw_level_1 = 1;
        if (cycles > 0) _tw_count_116 = _tw_count_116 + 1;
      end
    end

    // clk fall at 3070 ns
    @(timer(3070000000e-15 * time_scale, 10000000000e-15 * time_scale)) begin
      if ((cycles == 0) || (_tw_count_117 < cycles)) begin
        _tw_level_1 = 0;
        if (cycles > 0) _tw_count_117 = _tw_count_117 + 1;
      end
    end

    // clk rise at 3100 ns
    @(timer(3100000000e-15 * time_scale, 10000000000e-15 * time_scale)) begin
      if ((cycles == 0) || (_tw_count_118 < cycles)) begin
        _tw_level_1 = 1;
        if (cycles > 0) _tw_count_118 = _tw_count_118 + 1;
      end
    end

    // clk fall at 3120 ns
    @(timer(3120000000e-15 * time_scale, 10000000000e-15 * time_scale)) begin
      if ((cycles == 0) || (_tw_count_119 < cycles)) begin
        _tw_level_1 = 0;
        if (cycles > 0) _tw_count_119 = _tw_count_119 + 1;
      end
    end

    // clk rise at 3150 ns
    @(timer(3150000000e-15 * time_scale, 10000000000e-15 * time_scale)) begin
      if ((cycles == 0) || (_tw_count_120 < cycles)) begin
        _tw_level_1 = 1;
        if (cycles > 0) _tw_count_120 = _tw_count_120 + 1;
      end
    end

    // clk fall at 3170 ns
    @(timer(3170000000e-15 * time_scale, 10000000000e-15 * time_scale)) begin
      if ((cycles == 0) || (_tw_count_121 < cycles)) begin
        _tw_level_1 = 0;
        if (cycles > 0) _tw_count_121 = _tw_count_121 + 1;
      end
    end

    // clk rise at 3200 ns
    @(timer(3200000000e-15 * time_scale, 10000000000e-15 * time_scale)) begin
      if ((cycles == 0) || (_tw_count_122 < cycles)) begin
        _tw_level_1 = 1;
        if (cycles > 0) _tw_count_122 = _tw_count_122 + 1;
      end
    end

    // clk fall at 3220 ns
    @(timer(3220000000e-15 * time_scale, 10000000000e-15 * time_scale)) begin
      if ((cycles == 0) || (_tw_count_123 < cycles)) begin
        _tw_level_1 = 0;
        if (cycles > 0) _tw_count_123 = _tw_count_123 + 1;
      end
    end

    // clk rise at 3250 ns
    @(timer(3250000000e-15 * time_scale, 10000000000e-15 * time_scale)) begin
      if ((cycles == 0) || (_tw_count_124 < cycles)) begin
        _tw_level_1 = 1;
        if (cycles > 0) _tw_count_124 = _tw_count_124 + 1;
      end
    end

    // clk fall at 3270 ns
    @(timer(3270000000e-15 * time_scale, 10000000000e-15 * time_scale)) begin
      if ((cycles == 0) || (_tw_count_125 < cycles)) begin
        _tw_level_1 = 0;
        if (cycles > 0) _tw_count_125 = _tw_count_125 + 1;
      end
    end

    // clk rise at 3300 ns
    @(timer(3300000000e-15 * time_scale, 10000000000e-15 * time_scale)) begin
      if ((cycles == 0) || (_tw_count_126 < cycles)) begin
        _tw_level_1 = 1;
        if (cycles > 0) _tw_count_126 = _tw_count_126 + 1;
      end
    end

    // clk fall at 3320 ns
    @(timer(3320000000e-15 * time_scale, 10000000000e-15 * time_scale)) begin
      if ((cycles == 0) || (_tw_count_127 < cycles)) begin
        _tw_level_1 = 0;
        if (cycles > 0) _tw_count_127 = _tw_count_127 + 1;
      end
    end

    // clk rise at 3350 ns
    @(timer(3350000000e-15 * time_scale, 10000000000e-15 * time_scale)) begin
      if ((cycles == 0) || (_tw_count_128 < cycles)) begin
        _tw_level_1 = 1;
        if (cycles > 0) _tw_count_128 = _tw_count_128 + 1;
      end
    end

    // clk fall at 3370 ns
    @(timer(3370000000e-15 * time_scale, 10000000000e-15 * time_scale)) begin
      if ((cycles == 0) || (_tw_count_129 < cycles)) begin
        _tw_level_1 = 0;
        if (cycles > 0) _tw_count_129 = _tw_count_129 + 1;
      end
    end

    // clk rise at 3400 ns
    @(timer(3400000000e-15 * time_scale, 10000000000e-15 * time_scale)) begin
      if ((cycles == 0) || (_tw_count_130 < cycles)) begin
        _tw_level_1 = 1;
        if (cycles > 0) _tw_count_130 = _tw_count_130 + 1;
      end
    end

    // clk fall at 3420 ns
    @(timer(3420000000e-15 * time_scale, 10000000000e-15 * time_scale)) begin
      if ((cycles == 0) || (_tw_count_131 < cycles)) begin
        _tw_level_1 = 0;
        if (cycles > 0) _tw_count_131 = _tw_count_131 + 1;
      end
    end

    // clk rise at 3450 ns
    @(timer(3450000000e-15 * time_scale, 10000000000e-15 * time_scale)) begin
      if ((cycles == 0) || (_tw_count_132 < cycles)) begin
        _tw_level_1 = 1;
        if (cycles > 0) _tw_count_132 = _tw_count_132 + 1;
      end
    end

    // clk fall at 3470 ns
    @(timer(3470000000e-15 * time_scale, 10000000000e-15 * time_scale)) begin
      if ((cycles == 0) || (_tw_count_133 < cycles)) begin
        _tw_level_1 = 0;
        if (cycles > 0) _tw_count_133 = _tw_count_133 + 1;
      end
    end

    // clk rise at 3500 ns
    @(timer(3500000000e-15 * time_scale, 10000000000e-15 * time_scale)) begin
      if ((cycles == 0) || (_tw_count_134 < cycles)) begin
        _tw_level_1 = 1;
        if (cycles > 0) _tw_count_134 = _tw_count_134 + 1;
      end
    end

    // clk fall at 3520 ns
    @(timer(3520000000e-15 * time_scale, 10000000000e-15 * time_scale)) begin
      if ((cycles == 0) || (_tw_count_135 < cycles)) begin
        _tw_level_1 = 0;
        if (cycles > 0) _tw_count_135 = _tw_count_135 + 1;
      end
    end

    // clk rise at 3550 ns
    @(timer(3550000000e-15 * time_scale, 10000000000e-15 * time_scale)) begin
      if ((cycles == 0) || (_tw_count_136 < cycles)) begin
        _tw_level_1 = 1;
        if (cycles > 0) _tw_count_136 = _tw_count_136 + 1;
      end
    end

    // clk fall at 3570 ns
    @(timer(3570000000e-15 * time_scale, 10000000000e-15 * time_scale)) begin
      if ((cycles == 0) || (_tw_count_137 < cycles)) begin
        _tw_level_1 = 0;
        if (cycles > 0) _tw_count_137 = _tw_count_137 + 1;
      end
    end

    // clk rise at 3600 ns
    @(timer(3600000000e-15 * time_scale, 10000000000e-15 * time_scale)) begin
      if ((cycles == 0) || (_tw_count_138 < cycles)) begin
        _tw_level_1 = 1;
        if (cycles > 0) _tw_count_138 = _tw_count_138 + 1;
      end
    end

    // clk fall at 3620 ns
    @(timer(3620000000e-15 * time_scale, 10000000000e-15 * time_scale)) begin
      if ((cycles == 0) || (_tw_count_139 < cycles)) begin
        _tw_level_1 = 0;
        if (cycles > 0) _tw_count_139 = _tw_count_139 + 1;
      end
    end

    // clk rise at 3650 ns
    @(timer(3650000000e-15 * time_scale, 10000000000e-15 * time_scale)) begin
      if ((cycles == 0) || (_tw_count_140 < cycles)) begin
        _tw_level_1 = 1;
        if (cycles > 0) _tw_count_140 = _tw_count_140 + 1;
      end
    end

    // clk fall at 3670 ns
    @(timer(3670000000e-15 * time_scale, 10000000000e-15 * time_scale)) begin
      if ((cycles == 0) || (_tw_count_141 < cycles)) begin
        _tw_level_1 = 0;
        if (cycles > 0) _tw_count_141 = _tw_count_141 + 1;
      end
    end

    // clk rise at 3700 ns
    @(timer(3700000000e-15 * time_scale, 10000000000e-15 * time_scale)) begin
      if ((cycles == 0) || (_tw_count_142 < cycles)) begin
        _tw_level_1 = 1;
        if (cycles > 0) _tw_count_142 = _tw_count_142 + 1;
      end
    end

    // clk fall at 3720 ns
    @(timer(3720000000e-15 * time_scale, 10000000000e-15 * time_scale)) begin
      if ((cycles == 0) || (_tw_count_143 < cycles)) begin
        _tw_level_1 = 0;
        if (cycles > 0) _tw_count_143 = _tw_count_143 + 1;
      end
    end

    // clk rise at 3750 ns
    @(timer(3750000000e-15 * time_scale, 10000000000e-15 * time_scale)) begin
      if ((cycles == 0) || (_tw_count_144 < cycles)) begin
        _tw_level_1 = 1;
        if (cycles > 0) _tw_count_144 = _tw_count_144 + 1;
      end
    end

    // clk fall at 3770 ns
    @(timer(3770000000e-15 * time_scale, 10000000000e-15 * time_scale)) begin
      if ((cycles == 0) || (_tw_count_145 < cycles)) begin
        _tw_level_1 = 0;
        if (cycles > 0) _tw_count_145 = _tw_count_145 + 1;
      end
    end

    // clk rise at 3800 ns
    @(timer(3800000000e-15 * time_scale, 10000000000e-15 * time_scale)) begin
      if ((cycles == 0) || (_tw_count_146 < cycles)) begin
        _tw_level_1 = 1;
        if (cycles > 0) _tw_count_146 = _tw_count_146 + 1;
      end
    end

    // clk fall at 3820 ns
    @(timer(3820000000e-15 * time_scale, 10000000000e-15 * time_scale)) begin
      if ((cycles == 0) || (_tw_count_147 < cycles)) begin
        _tw_level_1 = 0;
        if (cycles > 0) _tw_count_147 = _tw_count_147 + 1;
      end
    end

    // clk rise at 3850 ns
    @(timer(3850000000e-15 * time_scale, 10000000000e-15 * time_scale)) begin
      if ((cycles == 0) || (_tw_count_148 < cycles)) begin
        _tw_level_1 = 1;
        if (cycles > 0) _tw_count_148 = _tw_count_148 + 1;
      end
    end

    // clk fall at 3870 ns
    @(timer(3870000000e-15 * time_scale, 10000000000e-15 * time_scale)) begin
      if ((cycles == 0) || (_tw_count_149 < cycles)) begin
        _tw_level_1 = 0;
        if (cycles > 0) _tw_count_149 = _tw_count_149 + 1;
      end
    end

    // clk rise at 3900 ns
    @(timer(3900000000e-15 * time_scale, 10000000000e-15 * time_scale)) begin
      if ((cycles == 0) || (_tw_count_150 < cycles)) begin
        _tw_level_1 = 1;
        if (cycles > 0) _tw_count_150 = _tw_count_150 + 1;
      end
    end

    // clk fall at 3920 ns
    @(timer(3920000000e-15 * time_scale, 10000000000e-15 * time_scale)) begin
      if ((cycles == 0) || (_tw_count_151 < cycles)) begin
        _tw_level_1 = 0;
        if (cycles > 0) _tw_count_151 = _tw_count_151 + 1;
      end
    end

    // clk rise at 3950 ns
    @(timer(3950000000e-15 * time_scale, 10000000000e-15 * time_scale)) begin
      if ((cycles == 0) || (_tw_count_152 < cycles)) begin
        _tw_level_1 = 1;
        if (cycles > 0) _tw_count_152 = _tw_count_152 + 1;
      end
    end

    // clk fall at 3970 ns
    @(timer(3970000000e-15 * time_scale, 10000000000e-15 * time_scale)) begin
      if ((cycles == 0) || (_tw_count_153 < cycles)) begin
        _tw_level_1 = 0;
        if (cycles > 0) _tw_count_153 = _tw_count_153 + 1;
      end
    end

    // clk rise at 4000 ns
    @(timer(4000000000e-15 * time_scale, 10000000000e-15 * time_scale)) begin
      if ((cycles == 0) || (_tw_count_154 < cycles)) begin
        _tw_level_1 = 1;
        if (cycles > 0) _tw_count_154 = _tw_count_154 + 1;
      end
    end

    // clk fall at 4020 ns
    @(timer(4020000000e-15 * time_scale, 10000000000e-15 * time_scale)) begin
      if ((cycles == 0) || (_tw_count_155 < cycles)) begin
        _tw_level_1 = 0;
        if (cycles > 0) _tw_count_155 = _tw_count_155 + 1;
      end
    end

    // clk rise at 4050 ns
    @(timer(4050000000e-15 * time_scale, 10000000000e-15 * time_scale)) begin
      if ((cycles == 0) || (_tw_count_156 < cycles)) begin
        _tw_level_1 = 1;
        if (cycles > 0) _tw_count_156 = _tw_count_156 + 1;
      end
    end

    // clk fall at 4070 ns
    @(timer(4070000000e-15 * time_scale, 10000000000e-15 * time_scale)) begin
      if ((cycles == 0) || (_tw_count_157 < cycles)) begin
        _tw_level_1 = 0;
        if (cycles > 0) _tw_count_157 = _tw_count_157 + 1;
      end
    end

    // clk rise at 4100 ns
    @(timer(4100000000e-15 * time_scale, 10000000000e-15 * time_scale)) begin
      if ((cycles == 0) || (_tw_count_158 < cycles)) begin
        _tw_level_1 = 1;
        if (cycles > 0) _tw_count_158 = _tw_count_158 + 1;
      end
    end

    // clk fall at 4120 ns
    @(timer(4120000000e-15 * time_scale, 10000000000e-15 * time_scale)) begin
      if ((cycles == 0) || (_tw_count_159 < cycles)) begin
        _tw_level_1 = 0;
        if (cycles > 0) _tw_count_159 = _tw_count_159 + 1;
      end
    end

    // clk rise at 4150 ns
    @(timer(4150000000e-15 * time_scale, 10000000000e-15 * time_scale)) begin
      if ((cycles == 0) || (_tw_count_160 < cycles)) begin
        _tw_level_1 = 1;
        if (cycles > 0) _tw_count_160 = _tw_count_160 + 1;
      end
    end

    // clk fall at 4170 ns
    @(timer(4170000000e-15 * time_scale, 10000000000e-15 * time_scale)) begin
      if ((cycles == 0) || (_tw_count_161 < cycles)) begin
        _tw_level_1 = 0;
        if (cycles > 0) _tw_count_161 = _tw_count_161 + 1;
      end
    end

    // clk rise at 4200 ns
    @(timer(4200000000e-15 * time_scale, 10000000000e-15 * time_scale)) begin
      if ((cycles == 0) || (_tw_count_162 < cycles)) begin
        _tw_level_1 = 1;
        if (cycles > 0) _tw_count_162 = _tw_count_162 + 1;
      end
    end

    // clk fall at 4220 ns
    @(timer(4220000000e-15 * time_scale, 10000000000e-15 * time_scale)) begin
      if ((cycles == 0) || (_tw_count_163 < cycles)) begin
        _tw_level_1 = 0;
        if (cycles > 0) _tw_count_163 = _tw_count_163 + 1;
      end
    end

    // clk rise at 4250 ns
    @(timer(4250000000e-15 * time_scale, 10000000000e-15 * time_scale)) begin
      if ((cycles == 0) || (_tw_count_164 < cycles)) begin
        _tw_level_1 = 1;
        if (cycles > 0) _tw_count_164 = _tw_count_164 + 1;
      end
    end

    // clk fall at 4270 ns
    @(timer(4270000000e-15 * time_scale, 10000000000e-15 * time_scale)) begin
      if ((cycles == 0) || (_tw_count_165 < cycles)) begin
        _tw_level_1 = 0;
        if (cycles > 0) _tw_count_165 = _tw_count_165 + 1;
      end
    end

    // clk rise at 4300 ns
    @(timer(4300000000e-15 * time_scale, 10000000000e-15 * time_scale)) begin
      if ((cycles == 0) || (_tw_count_166 < cycles)) begin
        _tw_level_1 = 1;
        if (cycles > 0) _tw_count_166 = _tw_count_166 + 1;
      end
    end

    // clk fall at 4320 ns
    @(timer(4320000000e-15 * time_scale, 10000000000e-15 * time_scale)) begin
      if ((cycles == 0) || (_tw_count_167 < cycles)) begin
        _tw_level_1 = 0;
        if (cycles > 0) _tw_count_167 = _tw_count_167 + 1;
      end
    end

    // clk rise at 4350 ns
    @(timer(4350000000e-15 * time_scale, 10000000000e-15 * time_scale)) begin
      if ((cycles == 0) || (_tw_count_168 < cycles)) begin
        _tw_level_1 = 1;
        if (cycles > 0) _tw_count_168 = _tw_count_168 + 1;
      end
    end

    // clk fall at 4370 ns
    @(timer(4370000000e-15 * time_scale, 10000000000e-15 * time_scale)) begin
      if ((cycles == 0) || (_tw_count_169 < cycles)) begin
        _tw_level_1 = 0;
        if (cycles > 0) _tw_count_169 = _tw_count_169 + 1;
      end
    end

    // clk rise at 4400 ns
    @(timer(4400000000e-15 * time_scale, 10000000000e-15 * time_scale)) begin
      if ((cycles == 0) || (_tw_count_170 < cycles)) begin
        _tw_level_1 = 1;
        if (cycles > 0) _tw_count_170 = _tw_count_170 + 1;
      end
    end

    // clk fall at 4420 ns
    @(timer(4420000000e-15 * time_scale, 10000000000e-15 * time_scale)) begin
      if ((cycles == 0) || (_tw_count_171 < cycles)) begin
        _tw_level_1 = 0;
        if (cycles > 0) _tw_count_171 = _tw_count_171 + 1;
      end
    end

    // clk rise at 4450 ns
    @(timer(4450000000e-15 * time_scale, 10000000000e-15 * time_scale)) begin
      if ((cycles == 0) || (_tw_count_172 < cycles)) begin
        _tw_level_1 = 1;
        if (cycles > 0) _tw_count_172 = _tw_count_172 + 1;
      end
    end

    // clk fall at 4470 ns
    @(timer(4470000000e-15 * time_scale, 10000000000e-15 * time_scale)) begin
      if ((cycles == 0) || (_tw_count_173 < cycles)) begin
        _tw_level_1 = 0;
        if (cycles > 0) _tw_count_173 = _tw_count_173 + 1;
      end
    end

    // clk rise at 4500 ns
    @(timer(4500000000e-15 * time_scale, 10000000000e-15 * time_scale)) begin
      if ((cycles == 0) || (_tw_count_174 < cycles)) begin
        _tw_level_1 = 1;
        if (cycles > 0) _tw_count_174 = _tw_count_174 + 1;
      end
    end

    // clk fall at 4520 ns
    @(timer(4520000000e-15 * time_scale, 10000000000e-15 * time_scale)) begin
      if ((cycles == 0) || (_tw_count_175 < cycles)) begin
        _tw_level_1 = 0;
        if (cycles > 0) _tw_count_175 = _tw_count_175 + 1;
      end
    end

    // clk rise at 4550 ns
    @(timer(4550000000e-15 * time_scale, 10000000000e-15 * time_scale)) begin
      if ((cycles == 0) || (_tw_count_176 < cycles)) begin
        _tw_level_1 = 1;
        if (cycles > 0) _tw_count_176 = _tw_count_176 + 1;
      end
    end

    // clk fall at 4570 ns
    @(timer(4570000000e-15 * time_scale, 10000000000e-15 * time_scale)) begin
      if ((cycles == 0) || (_tw_count_177 < cycles)) begin
        _tw_level_1 = 0;
        if (cycles > 0) _tw_count_177 = _tw_count_177 + 1;
      end
    end

    // clk rise at 4600 ns
    @(timer(4600000000e-15 * time_scale, 10000000000e-15 * time_scale)) begin
      if ((cycles == 0) || (_tw_count_178 < cycles)) begin
        _tw_level_1 = 1;
        if (cycles > 0) _tw_count_178 = _tw_count_178 + 1;
      end
    end

    // clk fall at 4620 ns
    @(timer(4620000000e-15 * time_scale, 10000000000e-15 * time_scale)) begin
      if ((cycles == 0) || (_tw_count_179 < cycles)) begin
        _tw_level_1 = 0;
        if (cycles > 0) _tw_count_179 = _tw_count_179 + 1;
      end
    end

    // clk rise at 4650 ns
    @(timer(4650000000e-15 * time_scale, 10000000000e-15 * time_scale)) begin
      if ((cycles == 0) || (_tw_count_180 < cycles)) begin
        _tw_level_1 = 1;
        if (cycles > 0) _tw_count_180 = _tw_count_180 + 1;
      end
    end

    // clk fall at 4670 ns
    @(timer(4670000000e-15 * time_scale, 10000000000e-15 * time_scale)) begin
      if ((cycles == 0) || (_tw_count_181 < cycles)) begin
        _tw_level_1 = 0;
        if (cycles > 0) _tw_count_181 = _tw_count_181 + 1;
      end
    end

    // clk rise at 4700 ns
    @(timer(4700000000e-15 * time_scale, 10000000000e-15 * time_scale)) begin
      if ((cycles == 0) || (_tw_count_182 < cycles)) begin
        _tw_level_1 = 1;
        if (cycles > 0) _tw_count_182 = _tw_count_182 + 1;
      end
    end

    // clk fall at 4720 ns
    @(timer(4720000000e-15 * time_scale, 10000000000e-15 * time_scale)) begin
      if ((cycles == 0) || (_tw_count_183 < cycles)) begin
        _tw_level_1 = 0;
        if (cycles > 0) _tw_count_183 = _tw_count_183 + 1;
      end
    end

    // clk rise at 4750 ns
    @(timer(4750000000e-15 * time_scale, 10000000000e-15 * time_scale)) begin
      if ((cycles == 0) || (_tw_count_184 < cycles)) begin
        _tw_level_1 = 1;
        if (cycles > 0) _tw_count_184 = _tw_count_184 + 1;
      end
    end

    // clk fall at 4770 ns
    @(timer(4770000000e-15 * time_scale, 10000000000e-15 * time_scale)) begin
      if ((cycles == 0) || (_tw_count_185 < cycles)) begin
        _tw_level_1 = 0;
        if (cycles > 0) _tw_count_185 = _tw_count_185 + 1;
      end
    end

    // clk rise at 4800 ns
    @(timer(4800000000e-15 * time_scale, 10000000000e-15 * time_scale)) begin
      if ((cycles == 0) || (_tw_count_186 < cycles)) begin
        _tw_level_1 = 1;
        if (cycles > 0) _tw_count_186 = _tw_count_186 + 1;
      end
    end

    // clk fall at 4820 ns
    @(timer(4820000000e-15 * time_scale, 10000000000e-15 * time_scale)) begin
      if ((cycles == 0) || (_tw_count_187 < cycles)) begin
        _tw_level_1 = 0;
        if (cycles > 0) _tw_count_187 = _tw_count_187 + 1;
      end
    end

    // clk rise at 4850 ns
    @(timer(4850000000e-15 * time_scale, 10000000000e-15 * time_scale)) begin
      if ((cycles == 0) || (_tw_count_188 < cycles)) begin
        _tw_level_1 = 1;
        if (cycles > 0) _tw_count_188 = _tw_count_188 + 1;
      end
    end

    // clk fall at 4870 ns
    @(timer(4870000000e-15 * time_scale, 10000000000e-15 * time_scale)) begin
      if ((cycles == 0) || (_tw_count_189 < cycles)) begin
        _tw_level_1 = 0;
        if (cycles > 0) _tw_count_189 = _tw_count_189 + 1;
      end
    end

    // clk rise at 4900 ns
    @(timer(4900000000e-15 * time_scale, 10000000000e-15 * time_scale)) begin
      if ((cycles == 0) || (_tw_count_190 < cycles)) begin
        _tw_level_1 = 1;
        if (cycles > 0) _tw_count_190 = _tw_count_190 + 1;
      end
    end

    // clk fall at 4920 ns
    @(timer(4920000000e-15 * time_scale, 10000000000e-15 * time_scale)) begin
      if ((cycles == 0) || (_tw_count_191 < cycles)) begin
        _tw_level_1 = 0;
        if (cycles > 0) _tw_count_191 = _tw_count_191 + 1;
      end
    end

    // clk rise at 4950 ns
    @(timer(4950000000e-15 * time_scale, 10000000000e-15 * time_scale)) begin
      if ((cycles == 0) || (_tw_count_192 < cycles)) begin
        _tw_level_1 = 1;
        if (cycles > 0) _tw_count_192 = _tw_count_192 + 1;
      end
    end

    // clk fall at 4970 ns
    @(timer(4970000000e-15 * time_scale, 10000000000e-15 * time_scale)) begin
      if ((cycles == 0) || (_tw_count_193 < cycles)) begin
        _tw_level_1 = 0;
        if (cycles > 0) _tw_count_193 = _tw_count_193 + 1;
      end
    end

    // clk rise at 5000 ns
    @(timer(5000000000e-15 * time_scale, 10000000000e-15 * time_scale)) begin
      if ((cycles == 0) || (_tw_count_194 < cycles)) begin
        _tw_level_1 = 1;
        if (cycles > 0) _tw_count_194 = _tw_count_194 + 1;
      end
    end

    // clk fall at 5020 ns
    @(timer(5020000000e-15 * time_scale, 10000000000e-15 * time_scale)) begin
      if ((cycles == 0) || (_tw_count_195 < cycles)) begin
        _tw_level_1 = 0;
        if (cycles > 0) _tw_count_195 = _tw_count_195 + 1;
      end
    end

    // clk rise at 5050 ns
    @(timer(5050000000e-15 * time_scale, 10000000000e-15 * time_scale)) begin
      if ((cycles == 0) || (_tw_count_196 < cycles)) begin
        _tw_level_1 = 1;
        if (cycles > 0) _tw_count_196 = _tw_count_196 + 1;
      end
    end

    // clk fall at 5070 ns
    @(timer(5070000000e-15 * time_scale, 10000000000e-15 * time_scale)) begin
      if ((cycles == 0) || (_tw_count_197 < cycles)) begin
        _tw_level_1 = 0;
        if (cycles > 0) _tw_count_197 = _tw_count_197 + 1;
      end
    end

    // clk rise at 5100 ns
    @(timer(5100000000e-15 * time_scale, 10000000000e-15 * time_scale)) begin
      if ((cycles == 0) || (_tw_count_198 < cycles)) begin
        _tw_level_1 = 1;
        if (cycles > 0) _tw_count_198 = _tw_count_198 + 1;
      end
    end

    // clk fall at 5120 ns
    @(timer(5120000000e-15 * time_scale, 10000000000e-15 * time_scale)) begin
      if ((cycles == 0) || (_tw_count_199 < cycles)) begin
        _tw_level_1 = 0;
        if (cycles > 0) _tw_count_199 = _tw_count_199 + 1;
      end
    end

    // clk rise at 5150 ns
    @(timer(5150000000e-15 * time_scale, 10000000000e-15 * time_scale)) begin
      if ((cycles == 0) || (_tw_count_200 < cycles)) begin
        _tw_level_1 = 1;
        if (cycles > 0) _tw_count_200 = _tw_count_200 + 1;
      end
    end

    // clk fall at 5170 ns
    @(timer(5170000000e-15 * time_scale, 10000000000e-15 * time_scale)) begin
      if ((cycles == 0) || (_tw_count_201 < cycles)) begin
        _tw_level_1 = 0;
        if (cycles > 0) _tw_count_201 = _tw_count_201 + 1;
      end
    end

    // phi1 rise at 200 ns
    @(timer(200000000e-15 * time_scale, 10000000000e-15 * time_scale)) begin
      if ((cycles == 0) || (_tw_count_202 < cycles)) begin
        _tw_level_2 = 1;
        if (cycles > 0) _tw_count_202 = _tw_count_202 + 1;
      end
    end

    // phi1 fall at 220 ns
    @(timer(220000000e-15 * time_scale, 10000000000e-15 * time_scale)) begin
      if ((cycles == 0) || (_tw_count_203 < cycles)) begin
        _tw_level_2 = 0;
        if (cycles > 0) _tw_count_203 = _tw_count_203 + 1;
      end
    end

    // phi1 rise at 250 ns
    @(timer(250000000e-15 * time_scale, 10000000000e-15 * time_scale)) begin
      if ((cycles == 0) || (_tw_count_204 < cycles)) begin
        _tw_level_2 = 1;
        if (cycles > 0) _tw_count_204 = _tw_count_204 + 1;
      end
    end

    // phi1 fall at 270 ns
    @(timer(270000000e-15 * time_scale, 10000000000e-15 * time_scale)) begin
      if ((cycles == 0) || (_tw_count_205 < cycles)) begin
        _tw_level_2 = 0;
        if (cycles > 0) _tw_count_205 = _tw_count_205 + 1;
      end
    end

    // phi1 rise at 300 ns
    @(timer(300000000e-15 * time_scale, 10000000000e-15 * time_scale)) begin
      if ((cycles == 0) || (_tw_count_206 < cycles)) begin
        _tw_level_2 = 1;
        if (cycles > 0) _tw_count_206 = _tw_count_206 + 1;
      end
    end

    // phi1 fall at 320 ns
    @(timer(320000000e-15 * time_scale, 10000000000e-15 * time_scale)) begin
      if ((cycles == 0) || (_tw_count_207 < cycles)) begin
        _tw_level_2 = 0;
        if (cycles > 0) _tw_count_207 = _tw_count_207 + 1;
      end
    end

    // phi1 rise at 350 ns
    @(timer(350000000e-15 * time_scale, 10000000000e-15 * time_scale)) begin
      if ((cycles == 0) || (_tw_count_208 < cycles)) begin
        _tw_level_2 = 1;
        if (cycles > 0) _tw_count_208 = _tw_count_208 + 1;
      end
    end

    // phi1 fall at 370 ns
    @(timer(370000000e-15 * time_scale, 10000000000e-15 * time_scale)) begin
      if ((cycles == 0) || (_tw_count_209 < cycles)) begin
        _tw_level_2 = 0;
        if (cycles > 0) _tw_count_209 = _tw_count_209 + 1;
      end
    end

    // phi1 rise at 400 ns
    @(timer(400000000e-15 * time_scale, 10000000000e-15 * time_scale)) begin
      if ((cycles == 0) || (_tw_count_210 < cycles)) begin
        _tw_level_2 = 1;
        if (cycles > 0) _tw_count_210 = _tw_count_210 + 1;
      end
    end

    // phi1 fall at 420 ns
    @(timer(420000000e-15 * time_scale, 10000000000e-15 * time_scale)) begin
      if ((cycles == 0) || (_tw_count_211 < cycles)) begin
        _tw_level_2 = 0;
        if (cycles > 0) _tw_count_211 = _tw_count_211 + 1;
      end
    end

    // phi1 rise at 450 ns
    @(timer(450000000e-15 * time_scale, 10000000000e-15 * time_scale)) begin
      if ((cycles == 0) || (_tw_count_212 < cycles)) begin
        _tw_level_2 = 1;
        if (cycles > 0) _tw_count_212 = _tw_count_212 + 1;
      end
    end

    // phi1 fall at 470 ns
    @(timer(470000000e-15 * time_scale, 10000000000e-15 * time_scale)) begin
      if ((cycles == 0) || (_tw_count_213 < cycles)) begin
        _tw_level_2 = 0;
        if (cycles > 0) _tw_count_213 = _tw_count_213 + 1;
      end
    end

    // phi1 rise at 500 ns
    @(timer(500000000e-15 * time_scale, 10000000000e-15 * time_scale)) begin
      if ((cycles == 0) || (_tw_count_214 < cycles)) begin
        _tw_level_2 = 1;
        if (cycles > 0) _tw_count_214 = _tw_count_214 + 1;
      end
    end

    // phi1 fall at 520 ns
    @(timer(520000000e-15 * time_scale, 10000000000e-15 * time_scale)) begin
      if ((cycles == 0) || (_tw_count_215 < cycles)) begin
        _tw_level_2 = 0;
        if (cycles > 0) _tw_count_215 = _tw_count_215 + 1;
      end
    end

    // phi1 rise at 550 ns
    @(timer(550000000e-15 * time_scale, 10000000000e-15 * time_scale)) begin
      if ((cycles == 0) || (_tw_count_216 < cycles)) begin
        _tw_level_2 = 1;
        if (cycles > 0) _tw_count_216 = _tw_count_216 + 1;
      end
    end

    // phi1 fall at 570 ns
    @(timer(570000000e-15 * time_scale, 10000000000e-15 * time_scale)) begin
      if ((cycles == 0) || (_tw_count_217 < cycles)) begin
        _tw_level_2 = 0;
        if (cycles > 0) _tw_count_217 = _tw_count_217 + 1;
      end
    end

    // phi1 rise at 600 ns
    @(timer(600000000e-15 * time_scale, 10000000000e-15 * time_scale)) begin
      if ((cycles == 0) || (_tw_count_218 < cycles)) begin
        _tw_level_2 = 1;
        if (cycles > 0) _tw_count_218 = _tw_count_218 + 1;
      end
    end

    // phi1 fall at 620 ns
    @(timer(620000000e-15 * time_scale, 10000000000e-15 * time_scale)) begin
      if ((cycles == 0) || (_tw_count_219 < cycles)) begin
        _tw_level_2 = 0;
        if (cycles > 0) _tw_count_219 = _tw_count_219 + 1;
      end
    end

    // phi1 rise at 650 ns
    @(timer(650000000e-15 * time_scale, 10000000000e-15 * time_scale)) begin
      if ((cycles == 0) || (_tw_count_220 < cycles)) begin
        _tw_level_2 = 1;
        if (cycles > 0) _tw_count_220 = _tw_count_220 + 1;
      end
    end

    // phi1 fall at 670 ns
    @(timer(670000000e-15 * time_scale, 10000000000e-15 * time_scale)) begin
      if ((cycles == 0) || (_tw_count_221 < cycles)) begin
        _tw_level_2 = 0;
        if (cycles > 0) _tw_count_221 = _tw_count_221 + 1;
      end
    end

    // phi1 rise at 700 ns
    @(timer(700000000e-15 * time_scale, 10000000000e-15 * time_scale)) begin
      if ((cycles == 0) || (_tw_count_222 < cycles)) begin
        _tw_level_2 = 1;
        if (cycles > 0) _tw_count_222 = _tw_count_222 + 1;
      end
    end

    // phi1 fall at 720 ns
    @(timer(720000000e-15 * time_scale, 10000000000e-15 * time_scale)) begin
      if ((cycles == 0) || (_tw_count_223 < cycles)) begin
        _tw_level_2 = 0;
        if (cycles > 0) _tw_count_223 = _tw_count_223 + 1;
      end
    end

    // phi1 rise at 750 ns
    @(timer(750000000e-15 * time_scale, 10000000000e-15 * time_scale)) begin
      if ((cycles == 0) || (_tw_count_224 < cycles)) begin
        _tw_level_2 = 1;
        if (cycles > 0) _tw_count_224 = _tw_count_224 + 1;
      end
    end

    // phi1 fall at 770 ns
    @(timer(770000000e-15 * time_scale, 10000000000e-15 * time_scale)) begin
      if ((cycles == 0) || (_tw_count_225 < cycles)) begin
        _tw_level_2 = 0;
        if (cycles > 0) _tw_count_225 = _tw_count_225 + 1;
      end
    end

    // phi1 rise at 800 ns
    @(timer(800000000e-15 * time_scale, 10000000000e-15 * time_scale)) begin
      if ((cycles == 0) || (_tw_count_226 < cycles)) begin
        _tw_level_2 = 1;
        if (cycles > 0) _tw_count_226 = _tw_count_226 + 1;
      end
    end

    // phi1 fall at 820 ns
    @(timer(820000000e-15 * time_scale, 10000000000e-15 * time_scale)) begin
      if ((cycles == 0) || (_tw_count_227 < cycles)) begin
        _tw_level_2 = 0;
        if (cycles > 0) _tw_count_227 = _tw_count_227 + 1;
      end
    end

    // phi1 rise at 850 ns
    @(timer(850000000e-15 * time_scale, 10000000000e-15 * time_scale)) begin
      if ((cycles == 0) || (_tw_count_228 < cycles)) begin
        _tw_level_2 = 1;
        if (cycles > 0) _tw_count_228 = _tw_count_228 + 1;
      end
    end

    // phi1 fall at 870 ns
    @(timer(870000000e-15 * time_scale, 10000000000e-15 * time_scale)) begin
      if ((cycles == 0) || (_tw_count_229 < cycles)) begin
        _tw_level_2 = 0;
        if (cycles > 0) _tw_count_229 = _tw_count_229 + 1;
      end
    end

    // phi1 rise at 900 ns
    @(timer(900000000e-15 * time_scale, 10000000000e-15 * time_scale)) begin
      if ((cycles == 0) || (_tw_count_230 < cycles)) begin
        _tw_level_2 = 1;
        if (cycles > 0) _tw_count_230 = _tw_count_230 + 1;
      end
    end

    // phi1 fall at 920 ns
    @(timer(920000000e-15 * time_scale, 10000000000e-15 * time_scale)) begin
      if ((cycles == 0) || (_tw_count_231 < cycles)) begin
        _tw_level_2 = 0;
        if (cycles > 0) _tw_count_231 = _tw_count_231 + 1;
      end
    end

    // phi1 rise at 950 ns
    @(timer(950000000e-15 * time_scale, 10000000000e-15 * time_scale)) begin
      if ((cycles == 0) || (_tw_count_232 < cycles)) begin
        _tw_level_2 = 1;
        if (cycles > 0) _tw_count_232 = _tw_count_232 + 1;
      end
    end

    // phi1 fall at 970 ns
    @(timer(970000000e-15 * time_scale, 10000000000e-15 * time_scale)) begin
      if ((cycles == 0) || (_tw_count_233 < cycles)) begin
        _tw_level_2 = 0;
        if (cycles > 0) _tw_count_233 = _tw_count_233 + 1;
      end
    end

    // phi1 rise at 1000 ns
    @(timer(1000000000e-15 * time_scale, 10000000000e-15 * time_scale)) begin
      if ((cycles == 0) || (_tw_count_234 < cycles)) begin
        _tw_level_2 = 1;
        if (cycles > 0) _tw_count_234 = _tw_count_234 + 1;
      end
    end

    // phi1 fall at 1020 ns
    @(timer(1020000000e-15 * time_scale, 10000000000e-15 * time_scale)) begin
      if ((cycles == 0) || (_tw_count_235 < cycles)) begin
        _tw_level_2 = 0;
        if (cycles > 0) _tw_count_235 = _tw_count_235 + 1;
      end
    end

    // phi1 rise at 1050 ns
    @(timer(1050000000e-15 * time_scale, 10000000000e-15 * time_scale)) begin
      if ((cycles == 0) || (_tw_count_236 < cycles)) begin
        _tw_level_2 = 1;
        if (cycles > 0) _tw_count_236 = _tw_count_236 + 1;
      end
    end

    // phi1 fall at 1070 ns
    @(timer(1070000000e-15 * time_scale, 10000000000e-15 * time_scale)) begin
      if ((cycles == 0) || (_tw_count_237 < cycles)) begin
        _tw_level_2 = 0;
        if (cycles > 0) _tw_count_237 = _tw_count_237 + 1;
      end
    end

    // phi1 rise at 1100 ns
    @(timer(1100000000e-15 * time_scale, 10000000000e-15 * time_scale)) begin
      if ((cycles == 0) || (_tw_count_238 < cycles)) begin
        _tw_level_2 = 1;
        if (cycles > 0) _tw_count_238 = _tw_count_238 + 1;
      end
    end

    // phi1 fall at 1120 ns
    @(timer(1120000000e-15 * time_scale, 10000000000e-15 * time_scale)) begin
      if ((cycles == 0) || (_tw_count_239 < cycles)) begin
        _tw_level_2 = 0;
        if (cycles > 0) _tw_count_239 = _tw_count_239 + 1;
      end
    end

    // phi1 rise at 1150 ns
    @(timer(1150000000e-15 * time_scale, 10000000000e-15 * time_scale)) begin
      if ((cycles == 0) || (_tw_count_240 < cycles)) begin
        _tw_level_2 = 1;
        if (cycles > 0) _tw_count_240 = _tw_count_240 + 1;
      end
    end

    // phi1 fall at 1170 ns
    @(timer(1170000000e-15 * time_scale, 10000000000e-15 * time_scale)) begin
      if ((cycles == 0) || (_tw_count_241 < cycles)) begin
        _tw_level_2 = 0;
        if (cycles > 0) _tw_count_241 = _tw_count_241 + 1;
      end
    end

    // phi1 rise at 1200 ns
    @(timer(1200000000e-15 * time_scale, 10000000000e-15 * time_scale)) begin
      if ((cycles == 0) || (_tw_count_242 < cycles)) begin
        _tw_level_2 = 1;
        if (cycles > 0) _tw_count_242 = _tw_count_242 + 1;
      end
    end

    // phi1 fall at 1220 ns
    @(timer(1220000000e-15 * time_scale, 10000000000e-15 * time_scale)) begin
      if ((cycles == 0) || (_tw_count_243 < cycles)) begin
        _tw_level_2 = 0;
        if (cycles > 0) _tw_count_243 = _tw_count_243 + 1;
      end
    end

    // phi1 rise at 1250 ns
    @(timer(1250000000e-15 * time_scale, 10000000000e-15 * time_scale)) begin
      if ((cycles == 0) || (_tw_count_244 < cycles)) begin
        _tw_level_2 = 1;
        if (cycles > 0) _tw_count_244 = _tw_count_244 + 1;
      end
    end

    // phi1 fall at 1270 ns
    @(timer(1270000000e-15 * time_scale, 10000000000e-15 * time_scale)) begin
      if ((cycles == 0) || (_tw_count_245 < cycles)) begin
        _tw_level_2 = 0;
        if (cycles > 0) _tw_count_245 = _tw_count_245 + 1;
      end
    end

    // phi1 rise at 1300 ns
    @(timer(1300000000e-15 * time_scale, 10000000000e-15 * time_scale)) begin
      if ((cycles == 0) || (_tw_count_246 < cycles)) begin
        _tw_level_2 = 1;
        if (cycles > 0) _tw_count_246 = _tw_count_246 + 1;
      end
    end

    // phi1 fall at 1320 ns
    @(timer(1320000000e-15 * time_scale, 10000000000e-15 * time_scale)) begin
      if ((cycles == 0) || (_tw_count_247 < cycles)) begin
        _tw_level_2 = 0;
        if (cycles > 0) _tw_count_247 = _tw_count_247 + 1;
      end
    end

    // phi1 rise at 1350 ns
    @(timer(1350000000e-15 * time_scale, 10000000000e-15 * time_scale)) begin
      if ((cycles == 0) || (_tw_count_248 < cycles)) begin
        _tw_level_2 = 1;
        if (cycles > 0) _tw_count_248 = _tw_count_248 + 1;
      end
    end

    // phi1 fall at 1370 ns
    @(timer(1370000000e-15 * time_scale, 10000000000e-15 * time_scale)) begin
      if ((cycles == 0) || (_tw_count_249 < cycles)) begin
        _tw_level_2 = 0;
        if (cycles > 0) _tw_count_249 = _tw_count_249 + 1;
      end
    end

    // phi1 rise at 1400 ns
    @(timer(1400000000e-15 * time_scale, 10000000000e-15 * time_scale)) begin
      if ((cycles == 0) || (_tw_count_250 < cycles)) begin
        _tw_level_2 = 1;
        if (cycles > 0) _tw_count_250 = _tw_count_250 + 1;
      end
    end

    // phi1 fall at 1420 ns
    @(timer(1420000000e-15 * time_scale, 10000000000e-15 * time_scale)) begin
      if ((cycles == 0) || (_tw_count_251 < cycles)) begin
        _tw_level_2 = 0;
        if (cycles > 0) _tw_count_251 = _tw_count_251 + 1;
      end
    end

    // phi1 rise at 1450 ns
    @(timer(1450000000e-15 * time_scale, 10000000000e-15 * time_scale)) begin
      if ((cycles == 0) || (_tw_count_252 < cycles)) begin
        _tw_level_2 = 1;
        if (cycles > 0) _tw_count_252 = _tw_count_252 + 1;
      end
    end

    // phi1 fall at 1470 ns
    @(timer(1470000000e-15 * time_scale, 10000000000e-15 * time_scale)) begin
      if ((cycles == 0) || (_tw_count_253 < cycles)) begin
        _tw_level_2 = 0;
        if (cycles > 0) _tw_count_253 = _tw_count_253 + 1;
      end
    end

    // phi1 rise at 1500 ns
    @(timer(1500000000e-15 * time_scale, 10000000000e-15 * time_scale)) begin
      if ((cycles == 0) || (_tw_count_254 < cycles)) begin
        _tw_level_2 = 1;
        if (cycles > 0) _tw_count_254 = _tw_count_254 + 1;
      end
    end

    // phi1 fall at 1520 ns
    @(timer(1520000000e-15 * time_scale, 10000000000e-15 * time_scale)) begin
      if ((cycles == 0) || (_tw_count_255 < cycles)) begin
        _tw_level_2 = 0;
        if (cycles > 0) _tw_count_255 = _tw_count_255 + 1;
      end
    end

    // phi1 rise at 1550 ns
    @(timer(1550000000e-15 * time_scale, 10000000000e-15 * time_scale)) begin
      if ((cycles == 0) || (_tw_count_256 < cycles)) begin
        _tw_level_2 = 1;
        if (cycles > 0) _tw_count_256 = _tw_count_256 + 1;
      end
    end

    // phi1 fall at 1570 ns
    @(timer(1570000000e-15 * time_scale, 10000000000e-15 * time_scale)) begin
      if ((cycles == 0) || (_tw_count_257 < cycles)) begin
        _tw_level_2 = 0;
        if (cycles > 0) _tw_count_257 = _tw_count_257 + 1;
      end
    end

    // phi1 rise at 1600 ns
    @(timer(1600000000e-15 * time_scale, 10000000000e-15 * time_scale)) begin
      if ((cycles == 0) || (_tw_count_258 < cycles)) begin
        _tw_level_2 = 1;
        if (cycles > 0) _tw_count_258 = _tw_count_258 + 1;
      end
    end

    // phi1 fall at 1620 ns
    @(timer(1620000000e-15 * time_scale, 10000000000e-15 * time_scale)) begin
      if ((cycles == 0) || (_tw_count_259 < cycles)) begin
        _tw_level_2 = 0;
        if (cycles > 0) _tw_count_259 = _tw_count_259 + 1;
      end
    end

    // phi1 rise at 1650 ns
    @(timer(1650000000e-15 * time_scale, 10000000000e-15 * time_scale)) begin
      if ((cycles == 0) || (_tw_count_260 < cycles)) begin
        _tw_level_2 = 1;
        if (cycles > 0) _tw_count_260 = _tw_count_260 + 1;
      end
    end

    // phi1 fall at 1670 ns
    @(timer(1670000000e-15 * time_scale, 10000000000e-15 * time_scale)) begin
      if ((cycles == 0) || (_tw_count_261 < cycles)) begin
        _tw_level_2 = 0;
        if (cycles > 0) _tw_count_261 = _tw_count_261 + 1;
      end
    end

    // phi1 rise at 1700 ns
    @(timer(1700000000e-15 * time_scale, 10000000000e-15 * time_scale)) begin
      if ((cycles == 0) || (_tw_count_262 < cycles)) begin
        _tw_level_2 = 1;
        if (cycles > 0) _tw_count_262 = _tw_count_262 + 1;
      end
    end

    // phi1 fall at 1720 ns
    @(timer(1720000000e-15 * time_scale, 10000000000e-15 * time_scale)) begin
      if ((cycles == 0) || (_tw_count_263 < cycles)) begin
        _tw_level_2 = 0;
        if (cycles > 0) _tw_count_263 = _tw_count_263 + 1;
      end
    end

    // phi1 rise at 1750 ns
    @(timer(1750000000e-15 * time_scale, 10000000000e-15 * time_scale)) begin
      if ((cycles == 0) || (_tw_count_264 < cycles)) begin
        _tw_level_2 = 1;
        if (cycles > 0) _tw_count_264 = _tw_count_264 + 1;
      end
    end

    // phi1 fall at 1770 ns
    @(timer(1770000000e-15 * time_scale, 10000000000e-15 * time_scale)) begin
      if ((cycles == 0) || (_tw_count_265 < cycles)) begin
        _tw_level_2 = 0;
        if (cycles > 0) _tw_count_265 = _tw_count_265 + 1;
      end
    end

    // phi1 rise at 1800 ns
    @(timer(1800000000e-15 * time_scale, 10000000000e-15 * time_scale)) begin
      if ((cycles == 0) || (_tw_count_266 < cycles)) begin
        _tw_level_2 = 1;
        if (cycles > 0) _tw_count_266 = _tw_count_266 + 1;
      end
    end

    // phi1 fall at 1820 ns
    @(timer(1820000000e-15 * time_scale, 10000000000e-15 * time_scale)) begin
      if ((cycles == 0) || (_tw_count_267 < cycles)) begin
        _tw_level_2 = 0;
        if (cycles > 0) _tw_count_267 = _tw_count_267 + 1;
      end
    end

    // phi1 rise at 1850 ns
    @(timer(1850000000e-15 * time_scale, 10000000000e-15 * time_scale)) begin
      if ((cycles == 0) || (_tw_count_268 < cycles)) begin
        _tw_level_2 = 1;
        if (cycles > 0) _tw_count_268 = _tw_count_268 + 1;
      end
    end

    // phi1 fall at 1870 ns
    @(timer(1870000000e-15 * time_scale, 10000000000e-15 * time_scale)) begin
      if ((cycles == 0) || (_tw_count_269 < cycles)) begin
        _tw_level_2 = 0;
        if (cycles > 0) _tw_count_269 = _tw_count_269 + 1;
      end
    end

    // phi1 rise at 1900 ns
    @(timer(1900000000e-15 * time_scale, 10000000000e-15 * time_scale)) begin
      if ((cycles == 0) || (_tw_count_270 < cycles)) begin
        _tw_level_2 = 1;
        if (cycles > 0) _tw_count_270 = _tw_count_270 + 1;
      end
    end

    // phi1 fall at 1920 ns
    @(timer(1920000000e-15 * time_scale, 10000000000e-15 * time_scale)) begin
      if ((cycles == 0) || (_tw_count_271 < cycles)) begin
        _tw_level_2 = 0;
        if (cycles > 0) _tw_count_271 = _tw_count_271 + 1;
      end
    end

    // phi1 rise at 1950 ns
    @(timer(1950000000e-15 * time_scale, 10000000000e-15 * time_scale)) begin
      if ((cycles == 0) || (_tw_count_272 < cycles)) begin
        _tw_level_2 = 1;
        if (cycles > 0) _tw_count_272 = _tw_count_272 + 1;
      end
    end

    // phi1 fall at 1970 ns
    @(timer(1970000000e-15 * time_scale, 10000000000e-15 * time_scale)) begin
      if ((cycles == 0) || (_tw_count_273 < cycles)) begin
        _tw_level_2 = 0;
        if (cycles > 0) _tw_count_273 = _tw_count_273 + 1;
      end
    end

    // phi1 rise at 2000 ns
    @(timer(2000000000e-15 * time_scale, 10000000000e-15 * time_scale)) begin
      if ((cycles == 0) || (_tw_count_274 < cycles)) begin
        _tw_level_2 = 1;
        if (cycles > 0) _tw_count_274 = _tw_count_274 + 1;
      end
    end

    // phi1 fall at 2020 ns
    @(timer(2020000000e-15 * time_scale, 10000000000e-15 * time_scale)) begin
      if ((cycles == 0) || (_tw_count_275 < cycles)) begin
        _tw_level_2 = 0;
        if (cycles > 0) _tw_count_275 = _tw_count_275 + 1;
      end
    end

    // phi1 rise at 2050 ns
    @(timer(2050000000e-15 * time_scale, 10000000000e-15 * time_scale)) begin
      if ((cycles == 0) || (_tw_count_276 < cycles)) begin
        _tw_level_2 = 1;
        if (cycles > 0) _tw_count_276 = _tw_count_276 + 1;
      end
    end

    // phi1 fall at 2070 ns
    @(timer(2070000000e-15 * time_scale, 10000000000e-15 * time_scale)) begin
      if ((cycles == 0) || (_tw_count_277 < cycles)) begin
        _tw_level_2 = 0;
        if (cycles > 0) _tw_count_277 = _tw_count_277 + 1;
      end
    end

    // phi1 rise at 2100 ns
    @(timer(2100000000e-15 * time_scale, 10000000000e-15 * time_scale)) begin
      if ((cycles == 0) || (_tw_count_278 < cycles)) begin
        _tw_level_2 = 1;
        if (cycles > 0) _tw_count_278 = _tw_count_278 + 1;
      end
    end

    // phi1 fall at 2120 ns
    @(timer(2120000000e-15 * time_scale, 10000000000e-15 * time_scale)) begin
      if ((cycles == 0) || (_tw_count_279 < cycles)) begin
        _tw_level_2 = 0;
        if (cycles > 0) _tw_count_279 = _tw_count_279 + 1;
      end
    end

    // phi1 rise at 2150 ns
    @(timer(2150000000e-15 * time_scale, 10000000000e-15 * time_scale)) begin
      if ((cycles == 0) || (_tw_count_280 < cycles)) begin
        _tw_level_2 = 1;
        if (cycles > 0) _tw_count_280 = _tw_count_280 + 1;
      end
    end

    // phi1 fall at 2170 ns
    @(timer(2170000000e-15 * time_scale, 10000000000e-15 * time_scale)) begin
      if ((cycles == 0) || (_tw_count_281 < cycles)) begin
        _tw_level_2 = 0;
        if (cycles > 0) _tw_count_281 = _tw_count_281 + 1;
      end
    end

    // phi1 rise at 2200 ns
    @(timer(2200000000e-15 * time_scale, 10000000000e-15 * time_scale)) begin
      if ((cycles == 0) || (_tw_count_282 < cycles)) begin
        _tw_level_2 = 1;
        if (cycles > 0) _tw_count_282 = _tw_count_282 + 1;
      end
    end

    // phi1 fall at 2220 ns
    @(timer(2220000000e-15 * time_scale, 10000000000e-15 * time_scale)) begin
      if ((cycles == 0) || (_tw_count_283 < cycles)) begin
        _tw_level_2 = 0;
        if (cycles > 0) _tw_count_283 = _tw_count_283 + 1;
      end
    end

    // phi1 rise at 2250 ns
    @(timer(2250000000e-15 * time_scale, 10000000000e-15 * time_scale)) begin
      if ((cycles == 0) || (_tw_count_284 < cycles)) begin
        _tw_level_2 = 1;
        if (cycles > 0) _tw_count_284 = _tw_count_284 + 1;
      end
    end

    // phi1 fall at 2270 ns
    @(timer(2270000000e-15 * time_scale, 10000000000e-15 * time_scale)) begin
      if ((cycles == 0) || (_tw_count_285 < cycles)) begin
        _tw_level_2 = 0;
        if (cycles > 0) _tw_count_285 = _tw_count_285 + 1;
      end
    end

    // phi1 rise at 2300 ns
    @(timer(2300000000e-15 * time_scale, 10000000000e-15 * time_scale)) begin
      if ((cycles == 0) || (_tw_count_286 < cycles)) begin
        _tw_level_2 = 1;
        if (cycles > 0) _tw_count_286 = _tw_count_286 + 1;
      end
    end

    // phi1 fall at 2320 ns
    @(timer(2320000000e-15 * time_scale, 10000000000e-15 * time_scale)) begin
      if ((cycles == 0) || (_tw_count_287 < cycles)) begin
        _tw_level_2 = 0;
        if (cycles > 0) _tw_count_287 = _tw_count_287 + 1;
      end
    end

    // phi1 rise at 2350 ns
    @(timer(2350000000e-15 * time_scale, 10000000000e-15 * time_scale)) begin
      if ((cycles == 0) || (_tw_count_288 < cycles)) begin
        _tw_level_2 = 1;
        if (cycles > 0) _tw_count_288 = _tw_count_288 + 1;
      end
    end

    // phi1 fall at 2370 ns
    @(timer(2370000000e-15 * time_scale, 10000000000e-15 * time_scale)) begin
      if ((cycles == 0) || (_tw_count_289 < cycles)) begin
        _tw_level_2 = 0;
        if (cycles > 0) _tw_count_289 = _tw_count_289 + 1;
      end
    end

    // phi1 rise at 2400 ns
    @(timer(2400000000e-15 * time_scale, 10000000000e-15 * time_scale)) begin
      if ((cycles == 0) || (_tw_count_290 < cycles)) begin
        _tw_level_2 = 1;
        if (cycles > 0) _tw_count_290 = _tw_count_290 + 1;
      end
    end

    // phi1 fall at 2420 ns
    @(timer(2420000000e-15 * time_scale, 10000000000e-15 * time_scale)) begin
      if ((cycles == 0) || (_tw_count_291 < cycles)) begin
        _tw_level_2 = 0;
        if (cycles > 0) _tw_count_291 = _tw_count_291 + 1;
      end
    end

    // phi1 rise at 2450 ns
    @(timer(2450000000e-15 * time_scale, 10000000000e-15 * time_scale)) begin
      if ((cycles == 0) || (_tw_count_292 < cycles)) begin
        _tw_level_2 = 1;
        if (cycles > 0) _tw_count_292 = _tw_count_292 + 1;
      end
    end

    // phi1 fall at 2470 ns
    @(timer(2470000000e-15 * time_scale, 10000000000e-15 * time_scale)) begin
      if ((cycles == 0) || (_tw_count_293 < cycles)) begin
        _tw_level_2 = 0;
        if (cycles > 0) _tw_count_293 = _tw_count_293 + 1;
      end
    end

    // phi1 rise at 2500 ns
    @(timer(2500000000e-15 * time_scale, 10000000000e-15 * time_scale)) begin
      if ((cycles == 0) || (_tw_count_294 < cycles)) begin
        _tw_level_2 = 1;
        if (cycles > 0) _tw_count_294 = _tw_count_294 + 1;
      end
    end

    // phi1 fall at 2520 ns
    @(timer(2520000000e-15 * time_scale, 10000000000e-15 * time_scale)) begin
      if ((cycles == 0) || (_tw_count_295 < cycles)) begin
        _tw_level_2 = 0;
        if (cycles > 0) _tw_count_295 = _tw_count_295 + 1;
      end
    end

    // phi1 rise at 2550 ns
    @(timer(2550000000e-15 * time_scale, 10000000000e-15 * time_scale)) begin
      if ((cycles == 0) || (_tw_count_296 < cycles)) begin
        _tw_level_2 = 1;
        if (cycles > 0) _tw_count_296 = _tw_count_296 + 1;
      end
    end

    // phi1 fall at 2570 ns
    @(timer(2570000000e-15 * time_scale, 10000000000e-15 * time_scale)) begin
      if ((cycles == 0) || (_tw_count_297 < cycles)) begin
        _tw_level_2 = 0;
        if (cycles > 0) _tw_count_297 = _tw_count_297 + 1;
      end
    end

    // phi1 rise at 2600 ns
    @(timer(2600000000e-15 * time_scale, 10000000000e-15 * time_scale)) begin
      if ((cycles == 0) || (_tw_count_298 < cycles)) begin
        _tw_level_2 = 1;
        if (cycles > 0) _tw_count_298 = _tw_count_298 + 1;
      end
    end

    // phi1 fall at 2620 ns
    @(timer(2620000000e-15 * time_scale, 10000000000e-15 * time_scale)) begin
      if ((cycles == 0) || (_tw_count_299 < cycles)) begin
        _tw_level_2 = 0;
        if (cycles > 0) _tw_count_299 = _tw_count_299 + 1;
      end
    end

    // phi1 rise at 2650 ns
    @(timer(2650000000e-15 * time_scale, 10000000000e-15 * time_scale)) begin
      if ((cycles == 0) || (_tw_count_300 < cycles)) begin
        _tw_level_2 = 1;
        if (cycles > 0) _tw_count_300 = _tw_count_300 + 1;
      end
    end

    // phi1 fall at 2670 ns
    @(timer(2670000000e-15 * time_scale, 10000000000e-15 * time_scale)) begin
      if ((cycles == 0) || (_tw_count_301 < cycles)) begin
        _tw_level_2 = 0;
        if (cycles > 0) _tw_count_301 = _tw_count_301 + 1;
      end
    end

    // phi1 rise at 2700 ns
    @(timer(2700000000e-15 * time_scale, 10000000000e-15 * time_scale)) begin
      if ((cycles == 0) || (_tw_count_302 < cycles)) begin
        _tw_level_2 = 1;
        if (cycles > 0) _tw_count_302 = _tw_count_302 + 1;
      end
    end

    // phi1 fall at 2720 ns
    @(timer(2720000000e-15 * time_scale, 10000000000e-15 * time_scale)) begin
      if ((cycles == 0) || (_tw_count_303 < cycles)) begin
        _tw_level_2 = 0;
        if (cycles > 0) _tw_count_303 = _tw_count_303 + 1;
      end
    end

    // phi1 rise at 2750 ns
    @(timer(2750000000e-15 * time_scale, 10000000000e-15 * time_scale)) begin
      if ((cycles == 0) || (_tw_count_304 < cycles)) begin
        _tw_level_2 = 1;
        if (cycles > 0) _tw_count_304 = _tw_count_304 + 1;
      end
    end

    // phi1 fall at 2770 ns
    @(timer(2770000000e-15 * time_scale, 10000000000e-15 * time_scale)) begin
      if ((cycles == 0) || (_tw_count_305 < cycles)) begin
        _tw_level_2 = 0;
        if (cycles > 0) _tw_count_305 = _tw_count_305 + 1;
      end
    end

    // phi1 rise at 2800 ns
    @(timer(2800000000e-15 * time_scale, 10000000000e-15 * time_scale)) begin
      if ((cycles == 0) || (_tw_count_306 < cycles)) begin
        _tw_level_2 = 1;
        if (cycles > 0) _tw_count_306 = _tw_count_306 + 1;
      end
    end

    // phi1 fall at 2820 ns
    @(timer(2820000000e-15 * time_scale, 10000000000e-15 * time_scale)) begin
      if ((cycles == 0) || (_tw_count_307 < cycles)) begin
        _tw_level_2 = 0;
        if (cycles > 0) _tw_count_307 = _tw_count_307 + 1;
      end
    end

    // phi1 rise at 2850 ns
    @(timer(2850000000e-15 * time_scale, 10000000000e-15 * time_scale)) begin
      if ((cycles == 0) || (_tw_count_308 < cycles)) begin
        _tw_level_2 = 1;
        if (cycles > 0) _tw_count_308 = _tw_count_308 + 1;
      end
    end

    // phi1 fall at 2870 ns
    @(timer(2870000000e-15 * time_scale, 10000000000e-15 * time_scale)) begin
      if ((cycles == 0) || (_tw_count_309 < cycles)) begin
        _tw_level_2 = 0;
        if (cycles > 0) _tw_count_309 = _tw_count_309 + 1;
      end
    end

    // phi1 rise at 2900 ns
    @(timer(2900000000e-15 * time_scale, 10000000000e-15 * time_scale)) begin
      if ((cycles == 0) || (_tw_count_310 < cycles)) begin
        _tw_level_2 = 1;
        if (cycles > 0) _tw_count_310 = _tw_count_310 + 1;
      end
    end

    // phi1 fall at 2920 ns
    @(timer(2920000000e-15 * time_scale, 10000000000e-15 * time_scale)) begin
      if ((cycles == 0) || (_tw_count_311 < cycles)) begin
        _tw_level_2 = 0;
        if (cycles > 0) _tw_count_311 = _tw_count_311 + 1;
      end
    end

    // phi1 rise at 2950 ns
    @(timer(2950000000e-15 * time_scale, 10000000000e-15 * time_scale)) begin
      if ((cycles == 0) || (_tw_count_312 < cycles)) begin
        _tw_level_2 = 1;
        if (cycles > 0) _tw_count_312 = _tw_count_312 + 1;
      end
    end

    // phi1 fall at 2970 ns
    @(timer(2970000000e-15 * time_scale, 10000000000e-15 * time_scale)) begin
      if ((cycles == 0) || (_tw_count_313 < cycles)) begin
        _tw_level_2 = 0;
        if (cycles > 0) _tw_count_313 = _tw_count_313 + 1;
      end
    end

    // phi1 rise at 3000 ns
    @(timer(3000000000e-15 * time_scale, 10000000000e-15 * time_scale)) begin
      if ((cycles == 0) || (_tw_count_314 < cycles)) begin
        _tw_level_2 = 1;
        if (cycles > 0) _tw_count_314 = _tw_count_314 + 1;
      end
    end

    // phi1 fall at 3020 ns
    @(timer(3020000000e-15 * time_scale, 10000000000e-15 * time_scale)) begin
      if ((cycles == 0) || (_tw_count_315 < cycles)) begin
        _tw_level_2 = 0;
        if (cycles > 0) _tw_count_315 = _tw_count_315 + 1;
      end
    end

    // phi1 rise at 3050 ns
    @(timer(3050000000e-15 * time_scale, 10000000000e-15 * time_scale)) begin
      if ((cycles == 0) || (_tw_count_316 < cycles)) begin
        _tw_level_2 = 1;
        if (cycles > 0) _tw_count_316 = _tw_count_316 + 1;
      end
    end

    // phi1 fall at 3070 ns
    @(timer(3070000000e-15 * time_scale, 10000000000e-15 * time_scale)) begin
      if ((cycles == 0) || (_tw_count_317 < cycles)) begin
        _tw_level_2 = 0;
        if (cycles > 0) _tw_count_317 = _tw_count_317 + 1;
      end
    end

    // phi1 rise at 3100 ns
    @(timer(3100000000e-15 * time_scale, 10000000000e-15 * time_scale)) begin
      if ((cycles == 0) || (_tw_count_318 < cycles)) begin
        _tw_level_2 = 1;
        if (cycles > 0) _tw_count_318 = _tw_count_318 + 1;
      end
    end

    // phi1 fall at 3120 ns
    @(timer(3120000000e-15 * time_scale, 10000000000e-15 * time_scale)) begin
      if ((cycles == 0) || (_tw_count_319 < cycles)) begin
        _tw_level_2 = 0;
        if (cycles > 0) _tw_count_319 = _tw_count_319 + 1;
      end
    end

    // phi1 rise at 3150 ns
    @(timer(3150000000e-15 * time_scale, 10000000000e-15 * time_scale)) begin
      if ((cycles == 0) || (_tw_count_320 < cycles)) begin
        _tw_level_2 = 1;
        if (cycles > 0) _tw_count_320 = _tw_count_320 + 1;
      end
    end

    // phi1 fall at 3170 ns
    @(timer(3170000000e-15 * time_scale, 10000000000e-15 * time_scale)) begin
      if ((cycles == 0) || (_tw_count_321 < cycles)) begin
        _tw_level_2 = 0;
        if (cycles > 0) _tw_count_321 = _tw_count_321 + 1;
      end
    end

    // phi1 rise at 3200 ns
    @(timer(3200000000e-15 * time_scale, 10000000000e-15 * time_scale)) begin
      if ((cycles == 0) || (_tw_count_322 < cycles)) begin
        _tw_level_2 = 1;
        if (cycles > 0) _tw_count_322 = _tw_count_322 + 1;
      end
    end

    // phi1 fall at 3220 ns
    @(timer(3220000000e-15 * time_scale, 10000000000e-15 * time_scale)) begin
      if ((cycles == 0) || (_tw_count_323 < cycles)) begin
        _tw_level_2 = 0;
        if (cycles > 0) _tw_count_323 = _tw_count_323 + 1;
      end
    end

    // phi1 rise at 3250 ns
    @(timer(3250000000e-15 * time_scale, 10000000000e-15 * time_scale)) begin
      if ((cycles == 0) || (_tw_count_324 < cycles)) begin
        _tw_level_2 = 1;
        if (cycles > 0) _tw_count_324 = _tw_count_324 + 1;
      end
    end

    // phi1 fall at 3270 ns
    @(timer(3270000000e-15 * time_scale, 10000000000e-15 * time_scale)) begin
      if ((cycles == 0) || (_tw_count_325 < cycles)) begin
        _tw_level_2 = 0;
        if (cycles > 0) _tw_count_325 = _tw_count_325 + 1;
      end
    end

    // phi1 rise at 3300 ns
    @(timer(3300000000e-15 * time_scale, 10000000000e-15 * time_scale)) begin
      if ((cycles == 0) || (_tw_count_326 < cycles)) begin
        _tw_level_2 = 1;
        if (cycles > 0) _tw_count_326 = _tw_count_326 + 1;
      end
    end

    // phi1 fall at 3320 ns
    @(timer(3320000000e-15 * time_scale, 10000000000e-15 * time_scale)) begin
      if ((cycles == 0) || (_tw_count_327 < cycles)) begin
        _tw_level_2 = 0;
        if (cycles > 0) _tw_count_327 = _tw_count_327 + 1;
      end
    end

    // phi1 rise at 3350 ns
    @(timer(3350000000e-15 * time_scale, 10000000000e-15 * time_scale)) begin
      if ((cycles == 0) || (_tw_count_328 < cycles)) begin
        _tw_level_2 = 1;
        if (cycles > 0) _tw_count_328 = _tw_count_328 + 1;
      end
    end

    // phi1 fall at 3370 ns
    @(timer(3370000000e-15 * time_scale, 10000000000e-15 * time_scale)) begin
      if ((cycles == 0) || (_tw_count_329 < cycles)) begin
        _tw_level_2 = 0;
        if (cycles > 0) _tw_count_329 = _tw_count_329 + 1;
      end
    end

    // phi1 rise at 3400 ns
    @(timer(3400000000e-15 * time_scale, 10000000000e-15 * time_scale)) begin
      if ((cycles == 0) || (_tw_count_330 < cycles)) begin
        _tw_level_2 = 1;
        if (cycles > 0) _tw_count_330 = _tw_count_330 + 1;
      end
    end

    // phi1 fall at 3420 ns
    @(timer(3420000000e-15 * time_scale, 10000000000e-15 * time_scale)) begin
      if ((cycles == 0) || (_tw_count_331 < cycles)) begin
        _tw_level_2 = 0;
        if (cycles > 0) _tw_count_331 = _tw_count_331 + 1;
      end
    end

    // phi1 rise at 3450 ns
    @(timer(3450000000e-15 * time_scale, 10000000000e-15 * time_scale)) begin
      if ((cycles == 0) || (_tw_count_332 < cycles)) begin
        _tw_level_2 = 1;
        if (cycles > 0) _tw_count_332 = _tw_count_332 + 1;
      end
    end

    // phi1 fall at 3470 ns
    @(timer(3470000000e-15 * time_scale, 10000000000e-15 * time_scale)) begin
      if ((cycles == 0) || (_tw_count_333 < cycles)) begin
        _tw_level_2 = 0;
        if (cycles > 0) _tw_count_333 = _tw_count_333 + 1;
      end
    end

    // phi1 rise at 3500 ns
    @(timer(3500000000e-15 * time_scale, 10000000000e-15 * time_scale)) begin
      if ((cycles == 0) || (_tw_count_334 < cycles)) begin
        _tw_level_2 = 1;
        if (cycles > 0) _tw_count_334 = _tw_count_334 + 1;
      end
    end

    // phi1 fall at 3520 ns
    @(timer(3520000000e-15 * time_scale, 10000000000e-15 * time_scale)) begin
      if ((cycles == 0) || (_tw_count_335 < cycles)) begin
        _tw_level_2 = 0;
        if (cycles > 0) _tw_count_335 = _tw_count_335 + 1;
      end
    end

    // phi1 rise at 3550 ns
    @(timer(3550000000e-15 * time_scale, 10000000000e-15 * time_scale)) begin
      if ((cycles == 0) || (_tw_count_336 < cycles)) begin
        _tw_level_2 = 1;
        if (cycles > 0) _tw_count_336 = _tw_count_336 + 1;
      end
    end

    // phi1 fall at 3570 ns
    @(timer(3570000000e-15 * time_scale, 10000000000e-15 * time_scale)) begin
      if ((cycles == 0) || (_tw_count_337 < cycles)) begin
        _tw_level_2 = 0;
        if (cycles > 0) _tw_count_337 = _tw_count_337 + 1;
      end
    end

    // phi1 rise at 3600 ns
    @(timer(3600000000e-15 * time_scale, 10000000000e-15 * time_scale)) begin
      if ((cycles == 0) || (_tw_count_338 < cycles)) begin
        _tw_level_2 = 1;
        if (cycles > 0) _tw_count_338 = _tw_count_338 + 1;
      end
    end

    // phi1 fall at 3620 ns
    @(timer(3620000000e-15 * time_scale, 10000000000e-15 * time_scale)) begin
      if ((cycles == 0) || (_tw_count_339 < cycles)) begin
        _tw_level_2 = 0;
        if (cycles > 0) _tw_count_339 = _tw_count_339 + 1;
      end
    end

    // phi1 rise at 3650 ns
    @(timer(3650000000e-15 * time_scale, 10000000000e-15 * time_scale)) begin
      if ((cycles == 0) || (_tw_count_340 < cycles)) begin
        _tw_level_2 = 1;
        if (cycles > 0) _tw_count_340 = _tw_count_340 + 1;
      end
    end

    // phi1 fall at 3670 ns
    @(timer(3670000000e-15 * time_scale, 10000000000e-15 * time_scale)) begin
      if ((cycles == 0) || (_tw_count_341 < cycles)) begin
        _tw_level_2 = 0;
        if (cycles > 0) _tw_count_341 = _tw_count_341 + 1;
      end
    end

    // phi1 rise at 3700 ns
    @(timer(3700000000e-15 * time_scale, 10000000000e-15 * time_scale)) begin
      if ((cycles == 0) || (_tw_count_342 < cycles)) begin
        _tw_level_2 = 1;
        if (cycles > 0) _tw_count_342 = _tw_count_342 + 1;
      end
    end

    // phi1 fall at 3720 ns
    @(timer(3720000000e-15 * time_scale, 10000000000e-15 * time_scale)) begin
      if ((cycles == 0) || (_tw_count_343 < cycles)) begin
        _tw_level_2 = 0;
        if (cycles > 0) _tw_count_343 = _tw_count_343 + 1;
      end
    end

    // phi1 rise at 3750 ns
    @(timer(3750000000e-15 * time_scale, 10000000000e-15 * time_scale)) begin
      if ((cycles == 0) || (_tw_count_344 < cycles)) begin
        _tw_level_2 = 1;
        if (cycles > 0) _tw_count_344 = _tw_count_344 + 1;
      end
    end

    // phi1 fall at 3770 ns
    @(timer(3770000000e-15 * time_scale, 10000000000e-15 * time_scale)) begin
      if ((cycles == 0) || (_tw_count_345 < cycles)) begin
        _tw_level_2 = 0;
        if (cycles > 0) _tw_count_345 = _tw_count_345 + 1;
      end
    end

    // phi1 rise at 3800 ns
    @(timer(3800000000e-15 * time_scale, 10000000000e-15 * time_scale)) begin
      if ((cycles == 0) || (_tw_count_346 < cycles)) begin
        _tw_level_2 = 1;
        if (cycles > 0) _tw_count_346 = _tw_count_346 + 1;
      end
    end

    // phi1 fall at 3820 ns
    @(timer(3820000000e-15 * time_scale, 10000000000e-15 * time_scale)) begin
      if ((cycles == 0) || (_tw_count_347 < cycles)) begin
        _tw_level_2 = 0;
        if (cycles > 0) _tw_count_347 = _tw_count_347 + 1;
      end
    end

    // phi1 rise at 3850 ns
    @(timer(3850000000e-15 * time_scale, 10000000000e-15 * time_scale)) begin
      if ((cycles == 0) || (_tw_count_348 < cycles)) begin
        _tw_level_2 = 1;
        if (cycles > 0) _tw_count_348 = _tw_count_348 + 1;
      end
    end

    // phi1 fall at 3870 ns
    @(timer(3870000000e-15 * time_scale, 10000000000e-15 * time_scale)) begin
      if ((cycles == 0) || (_tw_count_349 < cycles)) begin
        _tw_level_2 = 0;
        if (cycles > 0) _tw_count_349 = _tw_count_349 + 1;
      end
    end

    // phi1 rise at 3900 ns
    @(timer(3900000000e-15 * time_scale, 10000000000e-15 * time_scale)) begin
      if ((cycles == 0) || (_tw_count_350 < cycles)) begin
        _tw_level_2 = 1;
        if (cycles > 0) _tw_count_350 = _tw_count_350 + 1;
      end
    end

    // phi1 fall at 3920 ns
    @(timer(3920000000e-15 * time_scale, 10000000000e-15 * time_scale)) begin
      if ((cycles == 0) || (_tw_count_351 < cycles)) begin
        _tw_level_2 = 0;
        if (cycles > 0) _tw_count_351 = _tw_count_351 + 1;
      end
    end

    // phi1 rise at 3950 ns
    @(timer(3950000000e-15 * time_scale, 10000000000e-15 * time_scale)) begin
      if ((cycles == 0) || (_tw_count_352 < cycles)) begin
        _tw_level_2 = 1;
        if (cycles > 0) _tw_count_352 = _tw_count_352 + 1;
      end
    end

    // phi1 fall at 3970 ns
    @(timer(3970000000e-15 * time_scale, 10000000000e-15 * time_scale)) begin
      if ((cycles == 0) || (_tw_count_353 < cycles)) begin
        _tw_level_2 = 0;
        if (cycles > 0) _tw_count_353 = _tw_count_353 + 1;
      end
    end

    // phi1 rise at 4000 ns
    @(timer(4000000000e-15 * time_scale, 10000000000e-15 * time_scale)) begin
      if ((cycles == 0) || (_tw_count_354 < cycles)) begin
        _tw_level_2 = 1;
        if (cycles > 0) _tw_count_354 = _tw_count_354 + 1;
      end
    end

    // phi1 fall at 4020 ns
    @(timer(4020000000e-15 * time_scale, 10000000000e-15 * time_scale)) begin
      if ((cycles == 0) || (_tw_count_355 < cycles)) begin
        _tw_level_2 = 0;
        if (cycles > 0) _tw_count_355 = _tw_count_355 + 1;
      end
    end

    // phi1 rise at 4050 ns
    @(timer(4050000000e-15 * time_scale, 10000000000e-15 * time_scale)) begin
      if ((cycles == 0) || (_tw_count_356 < cycles)) begin
        _tw_level_2 = 1;
        if (cycles > 0) _tw_count_356 = _tw_count_356 + 1;
      end
    end

    // phi1 fall at 4070 ns
    @(timer(4070000000e-15 * time_scale, 10000000000e-15 * time_scale)) begin
      if ((cycles == 0) || (_tw_count_357 < cycles)) begin
        _tw_level_2 = 0;
        if (cycles > 0) _tw_count_357 = _tw_count_357 + 1;
      end
    end

    // phi1 rise at 4100 ns
    @(timer(4100000000e-15 * time_scale, 10000000000e-15 * time_scale)) begin
      if ((cycles == 0) || (_tw_count_358 < cycles)) begin
        _tw_level_2 = 1;
        if (cycles > 0) _tw_count_358 = _tw_count_358 + 1;
      end
    end

    // phi1 fall at 4120 ns
    @(timer(4120000000e-15 * time_scale, 10000000000e-15 * time_scale)) begin
      if ((cycles == 0) || (_tw_count_359 < cycles)) begin
        _tw_level_2 = 0;
        if (cycles > 0) _tw_count_359 = _tw_count_359 + 1;
      end
    end

    // phi1 rise at 4150 ns
    @(timer(4150000000e-15 * time_scale, 10000000000e-15 * time_scale)) begin
      if ((cycles == 0) || (_tw_count_360 < cycles)) begin
        _tw_level_2 = 1;
        if (cycles > 0) _tw_count_360 = _tw_count_360 + 1;
      end
    end

    // phi1 fall at 4170 ns
    @(timer(4170000000e-15 * time_scale, 10000000000e-15 * time_scale)) begin
      if ((cycles == 0) || (_tw_count_361 < cycles)) begin
        _tw_level_2 = 0;
        if (cycles > 0) _tw_count_361 = _tw_count_361 + 1;
      end
    end

    // phi1 rise at 4200 ns
    @(timer(4200000000e-15 * time_scale, 10000000000e-15 * time_scale)) begin
      if ((cycles == 0) || (_tw_count_362 < cycles)) begin
        _tw_level_2 = 1;
        if (cycles > 0) _tw_count_362 = _tw_count_362 + 1;
      end
    end

    // phi1 fall at 4220 ns
    @(timer(4220000000e-15 * time_scale, 10000000000e-15 * time_scale)) begin
      if ((cycles == 0) || (_tw_count_363 < cycles)) begin
        _tw_level_2 = 0;
        if (cycles > 0) _tw_count_363 = _tw_count_363 + 1;
      end
    end

    // phi1 rise at 4250 ns
    @(timer(4250000000e-15 * time_scale, 10000000000e-15 * time_scale)) begin
      if ((cycles == 0) || (_tw_count_364 < cycles)) begin
        _tw_level_2 = 1;
        if (cycles > 0) _tw_count_364 = _tw_count_364 + 1;
      end
    end

    // phi1 fall at 4270 ns
    @(timer(4270000000e-15 * time_scale, 10000000000e-15 * time_scale)) begin
      if ((cycles == 0) || (_tw_count_365 < cycles)) begin
        _tw_level_2 = 0;
        if (cycles > 0) _tw_count_365 = _tw_count_365 + 1;
      end
    end

    // phi1 rise at 4300 ns
    @(timer(4300000000e-15 * time_scale, 10000000000e-15 * time_scale)) begin
      if ((cycles == 0) || (_tw_count_366 < cycles)) begin
        _tw_level_2 = 1;
        if (cycles > 0) _tw_count_366 = _tw_count_366 + 1;
      end
    end

    // phi1 fall at 4320 ns
    @(timer(4320000000e-15 * time_scale, 10000000000e-15 * time_scale)) begin
      if ((cycles == 0) || (_tw_count_367 < cycles)) begin
        _tw_level_2 = 0;
        if (cycles > 0) _tw_count_367 = _tw_count_367 + 1;
      end
    end

    // phi1 rise at 4350 ns
    @(timer(4350000000e-15 * time_scale, 10000000000e-15 * time_scale)) begin
      if ((cycles == 0) || (_tw_count_368 < cycles)) begin
        _tw_level_2 = 1;
        if (cycles > 0) _tw_count_368 = _tw_count_368 + 1;
      end
    end

    // phi1 fall at 4370 ns
    @(timer(4370000000e-15 * time_scale, 10000000000e-15 * time_scale)) begin
      if ((cycles == 0) || (_tw_count_369 < cycles)) begin
        _tw_level_2 = 0;
        if (cycles > 0) _tw_count_369 = _tw_count_369 + 1;
      end
    end

    // phi1 rise at 4400 ns
    @(timer(4400000000e-15 * time_scale, 10000000000e-15 * time_scale)) begin
      if ((cycles == 0) || (_tw_count_370 < cycles)) begin
        _tw_level_2 = 1;
        if (cycles > 0) _tw_count_370 = _tw_count_370 + 1;
      end
    end

    // phi1 fall at 4420 ns
    @(timer(4420000000e-15 * time_scale, 10000000000e-15 * time_scale)) begin
      if ((cycles == 0) || (_tw_count_371 < cycles)) begin
        _tw_level_2 = 0;
        if (cycles > 0) _tw_count_371 = _tw_count_371 + 1;
      end
    end

    // phi1 rise at 4450 ns
    @(timer(4450000000e-15 * time_scale, 10000000000e-15 * time_scale)) begin
      if ((cycles == 0) || (_tw_count_372 < cycles)) begin
        _tw_level_2 = 1;
        if (cycles > 0) _tw_count_372 = _tw_count_372 + 1;
      end
    end

    // phi1 fall at 4470 ns
    @(timer(4470000000e-15 * time_scale, 10000000000e-15 * time_scale)) begin
      if ((cycles == 0) || (_tw_count_373 < cycles)) begin
        _tw_level_2 = 0;
        if (cycles > 0) _tw_count_373 = _tw_count_373 + 1;
      end
    end

    // phi1 rise at 4500 ns
    @(timer(4500000000e-15 * time_scale, 10000000000e-15 * time_scale)) begin
      if ((cycles == 0) || (_tw_count_374 < cycles)) begin
        _tw_level_2 = 1;
        if (cycles > 0) _tw_count_374 = _tw_count_374 + 1;
      end
    end

    // phi1 fall at 4520 ns
    @(timer(4520000000e-15 * time_scale, 10000000000e-15 * time_scale)) begin
      if ((cycles == 0) || (_tw_count_375 < cycles)) begin
        _tw_level_2 = 0;
        if (cycles > 0) _tw_count_375 = _tw_count_375 + 1;
      end
    end

    // phi1 rise at 4550 ns
    @(timer(4550000000e-15 * time_scale, 10000000000e-15 * time_scale)) begin
      if ((cycles == 0) || (_tw_count_376 < cycles)) begin
        _tw_level_2 = 1;
        if (cycles > 0) _tw_count_376 = _tw_count_376 + 1;
      end
    end

    // phi1 fall at 4570 ns
    @(timer(4570000000e-15 * time_scale, 10000000000e-15 * time_scale)) begin
      if ((cycles == 0) || (_tw_count_377 < cycles)) begin
        _tw_level_2 = 0;
        if (cycles > 0) _tw_count_377 = _tw_count_377 + 1;
      end
    end

    // phi1 rise at 4600 ns
    @(timer(4600000000e-15 * time_scale, 10000000000e-15 * time_scale)) begin
      if ((cycles == 0) || (_tw_count_378 < cycles)) begin
        _tw_level_2 = 1;
        if (cycles > 0) _tw_count_378 = _tw_count_378 + 1;
      end
    end

    // phi1 fall at 4620 ns
    @(timer(4620000000e-15 * time_scale, 10000000000e-15 * time_scale)) begin
      if ((cycles == 0) || (_tw_count_379 < cycles)) begin
        _tw_level_2 = 0;
        if (cycles > 0) _tw_count_379 = _tw_count_379 + 1;
      end
    end

    // phi1 rise at 4650 ns
    @(timer(4650000000e-15 * time_scale, 10000000000e-15 * time_scale)) begin
      if ((cycles == 0) || (_tw_count_380 < cycles)) begin
        _tw_level_2 = 1;
        if (cycles > 0) _tw_count_380 = _tw_count_380 + 1;
      end
    end

    // phi1 fall at 4670 ns
    @(timer(4670000000e-15 * time_scale, 10000000000e-15 * time_scale)) begin
      if ((cycles == 0) || (_tw_count_381 < cycles)) begin
        _tw_level_2 = 0;
        if (cycles > 0) _tw_count_381 = _tw_count_381 + 1;
      end
    end

    // phi1 rise at 4700 ns
    @(timer(4700000000e-15 * time_scale, 10000000000e-15 * time_scale)) begin
      if ((cycles == 0) || (_tw_count_382 < cycles)) begin
        _tw_level_2 = 1;
        if (cycles > 0) _tw_count_382 = _tw_count_382 + 1;
      end
    end

    // phi1 fall at 4720 ns
    @(timer(4720000000e-15 * time_scale, 10000000000e-15 * time_scale)) begin
      if ((cycles == 0) || (_tw_count_383 < cycles)) begin
        _tw_level_2 = 0;
        if (cycles > 0) _tw_count_383 = _tw_count_383 + 1;
      end
    end

    // phi1 rise at 4750 ns
    @(timer(4750000000e-15 * time_scale, 10000000000e-15 * time_scale)) begin
      if ((cycles == 0) || (_tw_count_384 < cycles)) begin
        _tw_level_2 = 1;
        if (cycles > 0) _tw_count_384 = _tw_count_384 + 1;
      end
    end

    // phi1 fall at 4770 ns
    @(timer(4770000000e-15 * time_scale, 10000000000e-15 * time_scale)) begin
      if ((cycles == 0) || (_tw_count_385 < cycles)) begin
        _tw_level_2 = 0;
        if (cycles > 0) _tw_count_385 = _tw_count_385 + 1;
      end
    end

    // phi1 rise at 4800 ns
    @(timer(4800000000e-15 * time_scale, 10000000000e-15 * time_scale)) begin
      if ((cycles == 0) || (_tw_count_386 < cycles)) begin
        _tw_level_2 = 1;
        if (cycles > 0) _tw_count_386 = _tw_count_386 + 1;
      end
    end

    // phi1 fall at 4820 ns
    @(timer(4820000000e-15 * time_scale, 10000000000e-15 * time_scale)) begin
      if ((cycles == 0) || (_tw_count_387 < cycles)) begin
        _tw_level_2 = 0;
        if (cycles > 0) _tw_count_387 = _tw_count_387 + 1;
      end
    end

    // phi1 rise at 4850 ns
    @(timer(4850000000e-15 * time_scale, 10000000000e-15 * time_scale)) begin
      if ((cycles == 0) || (_tw_count_388 < cycles)) begin
        _tw_level_2 = 1;
        if (cycles > 0) _tw_count_388 = _tw_count_388 + 1;
      end
    end

    // phi1 fall at 4870 ns
    @(timer(4870000000e-15 * time_scale, 10000000000e-15 * time_scale)) begin
      if ((cycles == 0) || (_tw_count_389 < cycles)) begin
        _tw_level_2 = 0;
        if (cycles > 0) _tw_count_389 = _tw_count_389 + 1;
      end
    end

    // phi1 rise at 4900 ns
    @(timer(4900000000e-15 * time_scale, 10000000000e-15 * time_scale)) begin
      if ((cycles == 0) || (_tw_count_390 < cycles)) begin
        _tw_level_2 = 1;
        if (cycles > 0) _tw_count_390 = _tw_count_390 + 1;
      end
    end

    // phi1 fall at 4920 ns
    @(timer(4920000000e-15 * time_scale, 10000000000e-15 * time_scale)) begin
      if ((cycles == 0) || (_tw_count_391 < cycles)) begin
        _tw_level_2 = 0;
        if (cycles > 0) _tw_count_391 = _tw_count_391 + 1;
      end
    end

    // phi1 rise at 4950 ns
    @(timer(4950000000e-15 * time_scale, 10000000000e-15 * time_scale)) begin
      if ((cycles == 0) || (_tw_count_392 < cycles)) begin
        _tw_level_2 = 1;
        if (cycles > 0) _tw_count_392 = _tw_count_392 + 1;
      end
    end

    // phi1 fall at 4970 ns
    @(timer(4970000000e-15 * time_scale, 10000000000e-15 * time_scale)) begin
      if ((cycles == 0) || (_tw_count_393 < cycles)) begin
        _tw_level_2 = 0;
        if (cycles > 0) _tw_count_393 = _tw_count_393 + 1;
      end
    end

    // phi1 rise at 5000 ns
    @(timer(5000000000e-15 * time_scale, 10000000000e-15 * time_scale)) begin
      if ((cycles == 0) || (_tw_count_394 < cycles)) begin
        _tw_level_2 = 1;
        if (cycles > 0) _tw_count_394 = _tw_count_394 + 1;
      end
    end

    // phi1 fall at 5020 ns
    @(timer(5020000000e-15 * time_scale, 10000000000e-15 * time_scale)) begin
      if ((cycles == 0) || (_tw_count_395 < cycles)) begin
        _tw_level_2 = 0;
        if (cycles > 0) _tw_count_395 = _tw_count_395 + 1;
      end
    end

    // phi1 rise at 5050 ns
    @(timer(5050000000e-15 * time_scale, 10000000000e-15 * time_scale)) begin
      if ((cycles == 0) || (_tw_count_396 < cycles)) begin
        _tw_level_2 = 1;
        if (cycles > 0) _tw_count_396 = _tw_count_396 + 1;
      end
    end

    // phi1 fall at 5070 ns
    @(timer(5070000000e-15 * time_scale, 10000000000e-15 * time_scale)) begin
      if ((cycles == 0) || (_tw_count_397 < cycles)) begin
        _tw_level_2 = 0;
        if (cycles > 0) _tw_count_397 = _tw_count_397 + 1;
      end
    end

    // phi1 rise at 5100 ns
    @(timer(5100000000e-15 * time_scale, 10000000000e-15 * time_scale)) begin
      if ((cycles == 0) || (_tw_count_398 < cycles)) begin
        _tw_level_2 = 1;
        if (cycles > 0) _tw_count_398 = _tw_count_398 + 1;
      end
    end

    // phi1 fall at 5120 ns
    @(timer(5120000000e-15 * time_scale, 10000000000e-15 * time_scale)) begin
      if ((cycles == 0) || (_tw_count_399 < cycles)) begin
        _tw_level_2 = 0;
        if (cycles > 0) _tw_count_399 = _tw_count_399 + 1;
      end
    end

    // phi1 rise at 5150 ns
    @(timer(5150000000e-15 * time_scale, 10000000000e-15 * time_scale)) begin
      if ((cycles == 0) || (_tw_count_400 < cycles)) begin
        _tw_level_2 = 1;
        if (cycles > 0) _tw_count_400 = _tw_count_400 + 1;
      end
    end

    // phi1 fall at 5170 ns
    @(timer(5170000000e-15 * time_scale, 10000000000e-15 * time_scale)) begin
      if ((cycles == 0) || (_tw_count_401 < cycles)) begin
        _tw_level_2 = 0;
        if (cycles > 0) _tw_count_401 = _tw_count_401 + 1;
      end
    end

    // phi2 rise at 220.2 ns
    @(timer(220200000e-15 * time_scale, 10000000000e-15 * time_scale)) begin
      if ((cycles == 0) || (_tw_count_402 < cycles)) begin
        _tw_level_3 = 1;
        if (cycles > 0) _tw_count_402 = _tw_count_402 + 1;
      end
    end

    // phi2 fall at 249.8 ns
    @(timer(249800000e-15 * time_scale, 10000000000e-15 * time_scale)) begin
      if ((cycles == 0) || (_tw_count_403 < cycles)) begin
        _tw_level_3 = 0;
        if (cycles > 0) _tw_count_403 = _tw_count_403 + 1;
      end
    end

    // phi2 rise at 270.2 ns
    @(timer(270200000e-15 * time_scale, 10000000000e-15 * time_scale)) begin
      if ((cycles == 0) || (_tw_count_404 < cycles)) begin
        _tw_level_3 = 1;
        if (cycles > 0) _tw_count_404 = _tw_count_404 + 1;
      end
    end

    // phi2 fall at 299.8 ns
    @(timer(299800000e-15 * time_scale, 10000000000e-15 * time_scale)) begin
      if ((cycles == 0) || (_tw_count_405 < cycles)) begin
        _tw_level_3 = 0;
        if (cycles > 0) _tw_count_405 = _tw_count_405 + 1;
      end
    end

    // phi2 rise at 320.2 ns
    @(timer(320200000e-15 * time_scale, 10000000000e-15 * time_scale)) begin
      if ((cycles == 0) || (_tw_count_406 < cycles)) begin
        _tw_level_3 = 1;
        if (cycles > 0) _tw_count_406 = _tw_count_406 + 1;
      end
    end

    // phi2 fall at 349.8 ns
    @(timer(349800000e-15 * time_scale, 10000000000e-15 * time_scale)) begin
      if ((cycles == 0) || (_tw_count_407 < cycles)) begin
        _tw_level_3 = 0;
        if (cycles > 0) _tw_count_407 = _tw_count_407 + 1;
      end
    end

    // phi2 rise at 370.2 ns
    @(timer(370200000e-15 * time_scale, 10000000000e-15 * time_scale)) begin
      if ((cycles == 0) || (_tw_count_408 < cycles)) begin
        _tw_level_3 = 1;
        if (cycles > 0) _tw_count_408 = _tw_count_408 + 1;
      end
    end

    // phi2 fall at 399.8 ns
    @(timer(399800000e-15 * time_scale, 10000000000e-15 * time_scale)) begin
      if ((cycles == 0) || (_tw_count_409 < cycles)) begin
        _tw_level_3 = 0;
        if (cycles > 0) _tw_count_409 = _tw_count_409 + 1;
      end
    end

    // phi2 rise at 420.2 ns
    @(timer(420200000e-15 * time_scale, 10000000000e-15 * time_scale)) begin
      if ((cycles == 0) || (_tw_count_410 < cycles)) begin
        _tw_level_3 = 1;
        if (cycles > 0) _tw_count_410 = _tw_count_410 + 1;
      end
    end

    // phi2 fall at 449.8 ns
    @(timer(449800000e-15 * time_scale, 10000000000e-15 * time_scale)) begin
      if ((cycles == 0) || (_tw_count_411 < cycles)) begin
        _tw_level_3 = 0;
        if (cycles > 0) _tw_count_411 = _tw_count_411 + 1;
      end
    end

    // phi2 rise at 470.2 ns
    @(timer(470200000e-15 * time_scale, 10000000000e-15 * time_scale)) begin
      if ((cycles == 0) || (_tw_count_412 < cycles)) begin
        _tw_level_3 = 1;
        if (cycles > 0) _tw_count_412 = _tw_count_412 + 1;
      end
    end

    // phi2 fall at 499.8 ns
    @(timer(499800000e-15 * time_scale, 10000000000e-15 * time_scale)) begin
      if ((cycles == 0) || (_tw_count_413 < cycles)) begin
        _tw_level_3 = 0;
        if (cycles > 0) _tw_count_413 = _tw_count_413 + 1;
      end
    end

    // phi2 rise at 520.2 ns
    @(timer(520200000e-15 * time_scale, 10000000000e-15 * time_scale)) begin
      if ((cycles == 0) || (_tw_count_414 < cycles)) begin
        _tw_level_3 = 1;
        if (cycles > 0) _tw_count_414 = _tw_count_414 + 1;
      end
    end

    // phi2 fall at 549.8 ns
    @(timer(549800000e-15 * time_scale, 10000000000e-15 * time_scale)) begin
      if ((cycles == 0) || (_tw_count_415 < cycles)) begin
        _tw_level_3 = 0;
        if (cycles > 0) _tw_count_415 = _tw_count_415 + 1;
      end
    end

    // phi2 rise at 570.2 ns
    @(timer(570200000e-15 * time_scale, 10000000000e-15 * time_scale)) begin
      if ((cycles == 0) || (_tw_count_416 < cycles)) begin
        _tw_level_3 = 1;
        if (cycles > 0) _tw_count_416 = _tw_count_416 + 1;
      end
    end

    // phi2 fall at 599.8 ns
    @(timer(599800000e-15 * time_scale, 10000000000e-15 * time_scale)) begin
      if ((cycles == 0) || (_tw_count_417 < cycles)) begin
        _tw_level_3 = 0;
        if (cycles > 0) _tw_count_417 = _tw_count_417 + 1;
      end
    end

    // phi2 rise at 620.2 ns
    @(timer(620200000e-15 * time_scale, 10000000000e-15 * time_scale)) begin
      if ((cycles == 0) || (_tw_count_418 < cycles)) begin
        _tw_level_3 = 1;
        if (cycles > 0) _tw_count_418 = _tw_count_418 + 1;
      end
    end

    // phi2 fall at 649.8 ns
    @(timer(649800000e-15 * time_scale, 10000000000e-15 * time_scale)) begin
      if ((cycles == 0) || (_tw_count_419 < cycles)) begin
        _tw_level_3 = 0;
        if (cycles > 0) _tw_count_419 = _tw_count_419 + 1;
      end
    end

    // phi2 rise at 670.2 ns
    @(timer(670200000e-15 * time_scale, 10000000000e-15 * time_scale)) begin
      if ((cycles == 0) || (_tw_count_420 < cycles)) begin
        _tw_level_3 = 1;
        if (cycles > 0) _tw_count_420 = _tw_count_420 + 1;
      end
    end

    // phi2 fall at 699.8 ns
    @(timer(699800000e-15 * time_scale, 10000000000e-15 * time_scale)) begin
      if ((cycles == 0) || (_tw_count_421 < cycles)) begin
        _tw_level_3 = 0;
        if (cycles > 0) _tw_count_421 = _tw_count_421 + 1;
      end
    end

    // phi2 rise at 720.2 ns
    @(timer(720200000e-15 * time_scale, 10000000000e-15 * time_scale)) begin
      if ((cycles == 0) || (_tw_count_422 < cycles)) begin
        _tw_level_3 = 1;
        if (cycles > 0) _tw_count_422 = _tw_count_422 + 1;
      end
    end

    // phi2 fall at 749.8 ns
    @(timer(749800000e-15 * time_scale, 10000000000e-15 * time_scale)) begin
      if ((cycles == 0) || (_tw_count_423 < cycles)) begin
        _tw_level_3 = 0;
        if (cycles > 0) _tw_count_423 = _tw_count_423 + 1;
      end
    end

    // phi2 rise at 770.2 ns
    @(timer(770200000e-15 * time_scale, 10000000000e-15 * time_scale)) begin
      if ((cycles == 0) || (_tw_count_424 < cycles)) begin
        _tw_level_3 = 1;
        if (cycles > 0) _tw_count_424 = _tw_count_424 + 1;
      end
    end

    // phi2 fall at 799.8 ns
    @(timer(799800000e-15 * time_scale, 10000000000e-15 * time_scale)) begin
      if ((cycles == 0) || (_tw_count_425 < cycles)) begin
        _tw_level_3 = 0;
        if (cycles > 0) _tw_count_425 = _tw_count_425 + 1;
      end
    end

    // phi2 rise at 820.2 ns
    @(timer(820200000e-15 * time_scale, 10000000000e-15 * time_scale)) begin
      if ((cycles == 0) || (_tw_count_426 < cycles)) begin
        _tw_level_3 = 1;
        if (cycles > 0) _tw_count_426 = _tw_count_426 + 1;
      end
    end

    // phi2 fall at 849.8 ns
    @(timer(849800000e-15 * time_scale, 10000000000e-15 * time_scale)) begin
      if ((cycles == 0) || (_tw_count_427 < cycles)) begin
        _tw_level_3 = 0;
        if (cycles > 0) _tw_count_427 = _tw_count_427 + 1;
      end
    end

    // phi2 rise at 870.2 ns
    @(timer(870200000e-15 * time_scale, 10000000000e-15 * time_scale)) begin
      if ((cycles == 0) || (_tw_count_428 < cycles)) begin
        _tw_level_3 = 1;
        if (cycles > 0) _tw_count_428 = _tw_count_428 + 1;
      end
    end

    // phi2 fall at 899.8 ns
    @(timer(899800000e-15 * time_scale, 10000000000e-15 * time_scale)) begin
      if ((cycles == 0) || (_tw_count_429 < cycles)) begin
        _tw_level_3 = 0;
        if (cycles > 0) _tw_count_429 = _tw_count_429 + 1;
      end
    end

    // phi2 rise at 920.2 ns
    @(timer(920200000e-15 * time_scale, 10000000000e-15 * time_scale)) begin
      if ((cycles == 0) || (_tw_count_430 < cycles)) begin
        _tw_level_3 = 1;
        if (cycles > 0) _tw_count_430 = _tw_count_430 + 1;
      end
    end

    // phi2 fall at 949.8 ns
    @(timer(949800000e-15 * time_scale, 10000000000e-15 * time_scale)) begin
      if ((cycles == 0) || (_tw_count_431 < cycles)) begin
        _tw_level_3 = 0;
        if (cycles > 0) _tw_count_431 = _tw_count_431 + 1;
      end
    end

    // phi2 rise at 970.2 ns
    @(timer(970200000e-15 * time_scale, 10000000000e-15 * time_scale)) begin
      if ((cycles == 0) || (_tw_count_432 < cycles)) begin
        _tw_level_3 = 1;
        if (cycles > 0) _tw_count_432 = _tw_count_432 + 1;
      end
    end

    // phi2 fall at 999.8 ns
    @(timer(999800000e-15 * time_scale, 10000000000e-15 * time_scale)) begin
      if ((cycles == 0) || (_tw_count_433 < cycles)) begin
        _tw_level_3 = 0;
        if (cycles > 0) _tw_count_433 = _tw_count_433 + 1;
      end
    end

    // phi2 rise at 1020.2 ns
    @(timer(1020200000e-15 * time_scale, 10000000000e-15 * time_scale)) begin
      if ((cycles == 0) || (_tw_count_434 < cycles)) begin
        _tw_level_3 = 1;
        if (cycles > 0) _tw_count_434 = _tw_count_434 + 1;
      end
    end

    // phi2 fall at 1049.8 ns
    @(timer(1049800000e-15 * time_scale, 10000000000e-15 * time_scale)) begin
      if ((cycles == 0) || (_tw_count_435 < cycles)) begin
        _tw_level_3 = 0;
        if (cycles > 0) _tw_count_435 = _tw_count_435 + 1;
      end
    end

    // phi2 rise at 1070.2 ns
    @(timer(1070200000e-15 * time_scale, 10000000000e-15 * time_scale)) begin
      if ((cycles == 0) || (_tw_count_436 < cycles)) begin
        _tw_level_3 = 1;
        if (cycles > 0) _tw_count_436 = _tw_count_436 + 1;
      end
    end

    // phi2 fall at 1099.8 ns
    @(timer(1099800000e-15 * time_scale, 10000000000e-15 * time_scale)) begin
      if ((cycles == 0) || (_tw_count_437 < cycles)) begin
        _tw_level_3 = 0;
        if (cycles > 0) _tw_count_437 = _tw_count_437 + 1;
      end
    end

    // phi2 rise at 1120.2 ns
    @(timer(1120200000e-15 * time_scale, 10000000000e-15 * time_scale)) begin
      if ((cycles == 0) || (_tw_count_438 < cycles)) begin
        _tw_level_3 = 1;
        if (cycles > 0) _tw_count_438 = _tw_count_438 + 1;
      end
    end

    // phi2 fall at 1149.8 ns
    @(timer(1149800000e-15 * time_scale, 10000000000e-15 * time_scale)) begin
      if ((cycles == 0) || (_tw_count_439 < cycles)) begin
        _tw_level_3 = 0;
        if (cycles > 0) _tw_count_439 = _tw_count_439 + 1;
      end
    end

    // phi2 rise at 1170.2 ns
    @(timer(1170200000e-15 * time_scale, 10000000000e-15 * time_scale)) begin
      if ((cycles == 0) || (_tw_count_440 < cycles)) begin
        _tw_level_3 = 1;
        if (cycles > 0) _tw_count_440 = _tw_count_440 + 1;
      end
    end

    // phi2 fall at 1199.8 ns
    @(timer(1199800000e-15 * time_scale, 10000000000e-15 * time_scale)) begin
      if ((cycles == 0) || (_tw_count_441 < cycles)) begin
        _tw_level_3 = 0;
        if (cycles > 0) _tw_count_441 = _tw_count_441 + 1;
      end
    end

    // phi2 rise at 1220.2 ns
    @(timer(1220200000e-15 * time_scale, 10000000000e-15 * time_scale)) begin
      if ((cycles == 0) || (_tw_count_442 < cycles)) begin
        _tw_level_3 = 1;
        if (cycles > 0) _tw_count_442 = _tw_count_442 + 1;
      end
    end

    // phi2 fall at 1249.8 ns
    @(timer(1249800000e-15 * time_scale, 10000000000e-15 * time_scale)) begin
      if ((cycles == 0) || (_tw_count_443 < cycles)) begin
        _tw_level_3 = 0;
        if (cycles > 0) _tw_count_443 = _tw_count_443 + 1;
      end
    end

    // phi2 rise at 1270.2 ns
    @(timer(1270200000e-15 * time_scale, 10000000000e-15 * time_scale)) begin
      if ((cycles == 0) || (_tw_count_444 < cycles)) begin
        _tw_level_3 = 1;
        if (cycles > 0) _tw_count_444 = _tw_count_444 + 1;
      end
    end

    // phi2 fall at 1299.8 ns
    @(timer(1299800000e-15 * time_scale, 10000000000e-15 * time_scale)) begin
      if ((cycles == 0) || (_tw_count_445 < cycles)) begin
        _tw_level_3 = 0;
        if (cycles > 0) _tw_count_445 = _tw_count_445 + 1;
      end
    end

    // phi2 rise at 1320.2 ns
    @(timer(1320200000e-15 * time_scale, 10000000000e-15 * time_scale)) begin
      if ((cycles == 0) || (_tw_count_446 < cycles)) begin
        _tw_level_3 = 1;
        if (cycles > 0) _tw_count_446 = _tw_count_446 + 1;
      end
    end

    // phi2 fall at 1349.8 ns
    @(timer(1349800000e-15 * time_scale, 10000000000e-15 * time_scale)) begin
      if ((cycles == 0) || (_tw_count_447 < cycles)) begin
        _tw_level_3 = 0;
        if (cycles > 0) _tw_count_447 = _tw_count_447 + 1;
      end
    end

    // phi2 rise at 1370.2 ns
    @(timer(1370200000e-15 * time_scale, 10000000000e-15 * time_scale)) begin
      if ((cycles == 0) || (_tw_count_448 < cycles)) begin
        _tw_level_3 = 1;
        if (cycles > 0) _tw_count_448 = _tw_count_448 + 1;
      end
    end

    // phi2 fall at 1399.8 ns
    @(timer(1399800000e-15 * time_scale, 10000000000e-15 * time_scale)) begin
      if ((cycles == 0) || (_tw_count_449 < cycles)) begin
        _tw_level_3 = 0;
        if (cycles > 0) _tw_count_449 = _tw_count_449 + 1;
      end
    end

    // phi2 rise at 1420.2 ns
    @(timer(1420200000e-15 * time_scale, 10000000000e-15 * time_scale)) begin
      if ((cycles == 0) || (_tw_count_450 < cycles)) begin
        _tw_level_3 = 1;
        if (cycles > 0) _tw_count_450 = _tw_count_450 + 1;
      end
    end

    // phi2 fall at 1449.8 ns
    @(timer(1449800000e-15 * time_scale, 10000000000e-15 * time_scale)) begin
      if ((cycles == 0) || (_tw_count_451 < cycles)) begin
        _tw_level_3 = 0;
        if (cycles > 0) _tw_count_451 = _tw_count_451 + 1;
      end
    end

    // phi2 rise at 1470.2 ns
    @(timer(1470200000e-15 * time_scale, 10000000000e-15 * time_scale)) begin
      if ((cycles == 0) || (_tw_count_452 < cycles)) begin
        _tw_level_3 = 1;
        if (cycles > 0) _tw_count_452 = _tw_count_452 + 1;
      end
    end

    // phi2 fall at 1499.8 ns
    @(timer(1499800000e-15 * time_scale, 10000000000e-15 * time_scale)) begin
      if ((cycles == 0) || (_tw_count_453 < cycles)) begin
        _tw_level_3 = 0;
        if (cycles > 0) _tw_count_453 = _tw_count_453 + 1;
      end
    end

    // phi2 rise at 1520.2 ns
    @(timer(1520200000e-15 * time_scale, 10000000000e-15 * time_scale)) begin
      if ((cycles == 0) || (_tw_count_454 < cycles)) begin
        _tw_level_3 = 1;
        if (cycles > 0) _tw_count_454 = _tw_count_454 + 1;
      end
    end

    // phi2 fall at 1549.8 ns
    @(timer(1549800000e-15 * time_scale, 10000000000e-15 * time_scale)) begin
      if ((cycles == 0) || (_tw_count_455 < cycles)) begin
        _tw_level_3 = 0;
        if (cycles > 0) _tw_count_455 = _tw_count_455 + 1;
      end
    end

    // phi2 rise at 1570.2 ns
    @(timer(1570200000e-15 * time_scale, 10000000000e-15 * time_scale)) begin
      if ((cycles == 0) || (_tw_count_456 < cycles)) begin
        _tw_level_3 = 1;
        if (cycles > 0) _tw_count_456 = _tw_count_456 + 1;
      end
    end

    // phi2 fall at 1599.8 ns
    @(timer(1599800000e-15 * time_scale, 10000000000e-15 * time_scale)) begin
      if ((cycles == 0) || (_tw_count_457 < cycles)) begin
        _tw_level_3 = 0;
        if (cycles > 0) _tw_count_457 = _tw_count_457 + 1;
      end
    end

    // phi2 rise at 1620.2 ns
    @(timer(1620200000e-15 * time_scale, 10000000000e-15 * time_scale)) begin
      if ((cycles == 0) || (_tw_count_458 < cycles)) begin
        _tw_level_3 = 1;
        if (cycles > 0) _tw_count_458 = _tw_count_458 + 1;
      end
    end

    // phi2 fall at 1649.8 ns
    @(timer(1649800000e-15 * time_scale, 10000000000e-15 * time_scale)) begin
      if ((cycles == 0) || (_tw_count_459 < cycles)) begin
        _tw_level_3 = 0;
        if (cycles > 0) _tw_count_459 = _tw_count_459 + 1;
      end
    end

    // phi2 rise at 1670.2 ns
    @(timer(1670200000e-15 * time_scale, 10000000000e-15 * time_scale)) begin
      if ((cycles == 0) || (_tw_count_460 < cycles)) begin
        _tw_level_3 = 1;
        if (cycles > 0) _tw_count_460 = _tw_count_460 + 1;
      end
    end

    // phi2 fall at 1699.8 ns
    @(timer(1699800000e-15 * time_scale, 10000000000e-15 * time_scale)) begin
      if ((cycles == 0) || (_tw_count_461 < cycles)) begin
        _tw_level_3 = 0;
        if (cycles > 0) _tw_count_461 = _tw_count_461 + 1;
      end
    end

    // phi2 rise at 1720.2 ns
    @(timer(1720200000e-15 * time_scale, 10000000000e-15 * time_scale)) begin
      if ((cycles == 0) || (_tw_count_462 < cycles)) begin
        _tw_level_3 = 1;
        if (cycles > 0) _tw_count_462 = _tw_count_462 + 1;
      end
    end

    // phi2 fall at 1749.8 ns
    @(timer(1749800000e-15 * time_scale, 10000000000e-15 * time_scale)) begin
      if ((cycles == 0) || (_tw_count_463 < cycles)) begin
        _tw_level_3 = 0;
        if (cycles > 0) _tw_count_463 = _tw_count_463 + 1;
      end
    end

    // phi2 rise at 1770.2 ns
    @(timer(1770200000e-15 * time_scale, 10000000000e-15 * time_scale)) begin
      if ((cycles == 0) || (_tw_count_464 < cycles)) begin
        _tw_level_3 = 1;
        if (cycles > 0) _tw_count_464 = _tw_count_464 + 1;
      end
    end

    // phi2 fall at 1799.8 ns
    @(timer(1799800000e-15 * time_scale, 10000000000e-15 * time_scale)) begin
      if ((cycles == 0) || (_tw_count_465 < cycles)) begin
        _tw_level_3 = 0;
        if (cycles > 0) _tw_count_465 = _tw_count_465 + 1;
      end
    end

    // phi2 rise at 1820.2 ns
    @(timer(1820200000e-15 * time_scale, 10000000000e-15 * time_scale)) begin
      if ((cycles == 0) || (_tw_count_466 < cycles)) begin
        _tw_level_3 = 1;
        if (cycles > 0) _tw_count_466 = _tw_count_466 + 1;
      end
    end

    // phi2 fall at 1849.8 ns
    @(timer(1849800000e-15 * time_scale, 10000000000e-15 * time_scale)) begin
      if ((cycles == 0) || (_tw_count_467 < cycles)) begin
        _tw_level_3 = 0;
        if (cycles > 0) _tw_count_467 = _tw_count_467 + 1;
      end
    end

    // phi2 rise at 1870.2 ns
    @(timer(1870200000e-15 * time_scale, 10000000000e-15 * time_scale)) begin
      if ((cycles == 0) || (_tw_count_468 < cycles)) begin
        _tw_level_3 = 1;
        if (cycles > 0) _tw_count_468 = _tw_count_468 + 1;
      end
    end

    // phi2 fall at 1899.8 ns
    @(timer(1899800000e-15 * time_scale, 10000000000e-15 * time_scale)) begin
      if ((cycles == 0) || (_tw_count_469 < cycles)) begin
        _tw_level_3 = 0;
        if (cycles > 0) _tw_count_469 = _tw_count_469 + 1;
      end
    end

    // phi2 rise at 1920.2 ns
    @(timer(1920200000e-15 * time_scale, 10000000000e-15 * time_scale)) begin
      if ((cycles == 0) || (_tw_count_470 < cycles)) begin
        _tw_level_3 = 1;
        if (cycles > 0) _tw_count_470 = _tw_count_470 + 1;
      end
    end

    // phi2 fall at 1949.8 ns
    @(timer(1949800000e-15 * time_scale, 10000000000e-15 * time_scale)) begin
      if ((cycles == 0) || (_tw_count_471 < cycles)) begin
        _tw_level_3 = 0;
        if (cycles > 0) _tw_count_471 = _tw_count_471 + 1;
      end
    end

    // phi2 rise at 1970.2 ns
    @(timer(1970200000e-15 * time_scale, 10000000000e-15 * time_scale)) begin
      if ((cycles == 0) || (_tw_count_472 < cycles)) begin
        _tw_level_3 = 1;
        if (cycles > 0) _tw_count_472 = _tw_count_472 + 1;
      end
    end

    // phi2 fall at 1999.8 ns
    @(timer(1999800000e-15 * time_scale, 10000000000e-15 * time_scale)) begin
      if ((cycles == 0) || (_tw_count_473 < cycles)) begin
        _tw_level_3 = 0;
        if (cycles > 0) _tw_count_473 = _tw_count_473 + 1;
      end
    end

    // phi2 rise at 2020.2 ns
    @(timer(2020200000e-15 * time_scale, 10000000000e-15 * time_scale)) begin
      if ((cycles == 0) || (_tw_count_474 < cycles)) begin
        _tw_level_3 = 1;
        if (cycles > 0) _tw_count_474 = _tw_count_474 + 1;
      end
    end

    // phi2 fall at 2049.8 ns
    @(timer(2049800000e-15 * time_scale, 10000000000e-15 * time_scale)) begin
      if ((cycles == 0) || (_tw_count_475 < cycles)) begin
        _tw_level_3 = 0;
        if (cycles > 0) _tw_count_475 = _tw_count_475 + 1;
      end
    end

    // phi2 rise at 2070.2 ns
    @(timer(2070200000e-15 * time_scale, 10000000000e-15 * time_scale)) begin
      if ((cycles == 0) || (_tw_count_476 < cycles)) begin
        _tw_level_3 = 1;
        if (cycles > 0) _tw_count_476 = _tw_count_476 + 1;
      end
    end

    // phi2 fall at 2099.8 ns
    @(timer(2099800000e-15 * time_scale, 10000000000e-15 * time_scale)) begin
      if ((cycles == 0) || (_tw_count_477 < cycles)) begin
        _tw_level_3 = 0;
        if (cycles > 0) _tw_count_477 = _tw_count_477 + 1;
      end
    end

    // phi2 rise at 2120.2 ns
    @(timer(2120200000e-15 * time_scale, 10000000000e-15 * time_scale)) begin
      if ((cycles == 0) || (_tw_count_478 < cycles)) begin
        _tw_level_3 = 1;
        if (cycles > 0) _tw_count_478 = _tw_count_478 + 1;
      end
    end

    // phi2 fall at 2149.8 ns
    @(timer(2149800000e-15 * time_scale, 10000000000e-15 * time_scale)) begin
      if ((cycles == 0) || (_tw_count_479 < cycles)) begin
        _tw_level_3 = 0;
        if (cycles > 0) _tw_count_479 = _tw_count_479 + 1;
      end
    end

    // phi2 rise at 2170.2 ns
    @(timer(2170200000e-15 * time_scale, 10000000000e-15 * time_scale)) begin
      if ((cycles == 0) || (_tw_count_480 < cycles)) begin
        _tw_level_3 = 1;
        if (cycles > 0) _tw_count_480 = _tw_count_480 + 1;
      end
    end

    // phi2 fall at 2199.8 ns
    @(timer(2199800000e-15 * time_scale, 10000000000e-15 * time_scale)) begin
      if ((cycles == 0) || (_tw_count_481 < cycles)) begin
        _tw_level_3 = 0;
        if (cycles > 0) _tw_count_481 = _tw_count_481 + 1;
      end
    end

    // phi2 rise at 2220.2 ns
    @(timer(2220200000e-15 * time_scale, 10000000000e-15 * time_scale)) begin
      if ((cycles == 0) || (_tw_count_482 < cycles)) begin
        _tw_level_3 = 1;
        if (cycles > 0) _tw_count_482 = _tw_count_482 + 1;
      end
    end

    // phi2 fall at 2249.8 ns
    @(timer(2249800000e-15 * time_scale, 10000000000e-15 * time_scale)) begin
      if ((cycles == 0) || (_tw_count_483 < cycles)) begin
        _tw_level_3 = 0;
        if (cycles > 0) _tw_count_483 = _tw_count_483 + 1;
      end
    end

    // phi2 rise at 2270.2 ns
    @(timer(2270200000e-15 * time_scale, 10000000000e-15 * time_scale)) begin
      if ((cycles == 0) || (_tw_count_484 < cycles)) begin
        _tw_level_3 = 1;
        if (cycles > 0) _tw_count_484 = _tw_count_484 + 1;
      end
    end

    // phi2 fall at 2299.8 ns
    @(timer(2299800000e-15 * time_scale, 10000000000e-15 * time_scale)) begin
      if ((cycles == 0) || (_tw_count_485 < cycles)) begin
        _tw_level_3 = 0;
        if (cycles > 0) _tw_count_485 = _tw_count_485 + 1;
      end
    end

    // phi2 rise at 2320.2 ns
    @(timer(2320200000e-15 * time_scale, 10000000000e-15 * time_scale)) begin
      if ((cycles == 0) || (_tw_count_486 < cycles)) begin
        _tw_level_3 = 1;
        if (cycles > 0) _tw_count_486 = _tw_count_486 + 1;
      end
    end

    // phi2 fall at 2349.8 ns
    @(timer(2349800000e-15 * time_scale, 10000000000e-15 * time_scale)) begin
      if ((cycles == 0) || (_tw_count_487 < cycles)) begin
        _tw_level_3 = 0;
        if (cycles > 0) _tw_count_487 = _tw_count_487 + 1;
      end
    end

    // phi2 rise at 2370.2 ns
    @(timer(2370200000e-15 * time_scale, 10000000000e-15 * time_scale)) begin
      if ((cycles == 0) || (_tw_count_488 < cycles)) begin
        _tw_level_3 = 1;
        if (cycles > 0) _tw_count_488 = _tw_count_488 + 1;
      end
    end

    // phi2 fall at 2399.8 ns
    @(timer(2399800000e-15 * time_scale, 10000000000e-15 * time_scale)) begin
      if ((cycles == 0) || (_tw_count_489 < cycles)) begin
        _tw_level_3 = 0;
        if (cycles > 0) _tw_count_489 = _tw_count_489 + 1;
      end
    end

    // phi2 rise at 2420.2 ns
    @(timer(2420200000e-15 * time_scale, 10000000000e-15 * time_scale)) begin
      if ((cycles == 0) || (_tw_count_490 < cycles)) begin
        _tw_level_3 = 1;
        if (cycles > 0) _tw_count_490 = _tw_count_490 + 1;
      end
    end

    // phi2 fall at 2449.8 ns
    @(timer(2449800000e-15 * time_scale, 10000000000e-15 * time_scale)) begin
      if ((cycles == 0) || (_tw_count_491 < cycles)) begin
        _tw_level_3 = 0;
        if (cycles > 0) _tw_count_491 = _tw_count_491 + 1;
      end
    end

    // phi2 rise at 2470.2 ns
    @(timer(2470200000e-15 * time_scale, 10000000000e-15 * time_scale)) begin
      if ((cycles == 0) || (_tw_count_492 < cycles)) begin
        _tw_level_3 = 1;
        if (cycles > 0) _tw_count_492 = _tw_count_492 + 1;
      end
    end

    // phi2 fall at 2499.8 ns
    @(timer(2499800000e-15 * time_scale, 10000000000e-15 * time_scale)) begin
      if ((cycles == 0) || (_tw_count_493 < cycles)) begin
        _tw_level_3 = 0;
        if (cycles > 0) _tw_count_493 = _tw_count_493 + 1;
      end
    end

    // phi2 rise at 2520.2 ns
    @(timer(2520200000e-15 * time_scale, 10000000000e-15 * time_scale)) begin
      if ((cycles == 0) || (_tw_count_494 < cycles)) begin
        _tw_level_3 = 1;
        if (cycles > 0) _tw_count_494 = _tw_count_494 + 1;
      end
    end

    // phi2 fall at 2549.8 ns
    @(timer(2549800000e-15 * time_scale, 10000000000e-15 * time_scale)) begin
      if ((cycles == 0) || (_tw_count_495 < cycles)) begin
        _tw_level_3 = 0;
        if (cycles > 0) _tw_count_495 = _tw_count_495 + 1;
      end
    end

    // phi2 rise at 2570.2 ns
    @(timer(2570200000e-15 * time_scale, 10000000000e-15 * time_scale)) begin
      if ((cycles == 0) || (_tw_count_496 < cycles)) begin
        _tw_level_3 = 1;
        if (cycles > 0) _tw_count_496 = _tw_count_496 + 1;
      end
    end

    // phi2 fall at 2599.8 ns
    @(timer(2599800000e-15 * time_scale, 10000000000e-15 * time_scale)) begin
      if ((cycles == 0) || (_tw_count_497 < cycles)) begin
        _tw_level_3 = 0;
        if (cycles > 0) _tw_count_497 = _tw_count_497 + 1;
      end
    end

    // phi2 rise at 2620.2 ns
    @(timer(2620200000e-15 * time_scale, 10000000000e-15 * time_scale)) begin
      if ((cycles == 0) || (_tw_count_498 < cycles)) begin
        _tw_level_3 = 1;
        if (cycles > 0) _tw_count_498 = _tw_count_498 + 1;
      end
    end

    // phi2 fall at 2649.8 ns
    @(timer(2649800000e-15 * time_scale, 10000000000e-15 * time_scale)) begin
      if ((cycles == 0) || (_tw_count_499 < cycles)) begin
        _tw_level_3 = 0;
        if (cycles > 0) _tw_count_499 = _tw_count_499 + 1;
      end
    end

    // phi2 rise at 2670.2 ns
    @(timer(2670200000e-15 * time_scale, 10000000000e-15 * time_scale)) begin
      if ((cycles == 0) || (_tw_count_500 < cycles)) begin
        _tw_level_3 = 1;
        if (cycles > 0) _tw_count_500 = _tw_count_500 + 1;
      end
    end

    // phi2 fall at 2699.8 ns
    @(timer(2699800000e-15 * time_scale, 10000000000e-15 * time_scale)) begin
      if ((cycles == 0) || (_tw_count_501 < cycles)) begin
        _tw_level_3 = 0;
        if (cycles > 0) _tw_count_501 = _tw_count_501 + 1;
      end
    end

    // phi2 rise at 2720.2 ns
    @(timer(2720200000e-15 * time_scale, 10000000000e-15 * time_scale)) begin
      if ((cycles == 0) || (_tw_count_502 < cycles)) begin
        _tw_level_3 = 1;
        if (cycles > 0) _tw_count_502 = _tw_count_502 + 1;
      end
    end

    // phi2 fall at 2749.8 ns
    @(timer(2749800000e-15 * time_scale, 10000000000e-15 * time_scale)) begin
      if ((cycles == 0) || (_tw_count_503 < cycles)) begin
        _tw_level_3 = 0;
        if (cycles > 0) _tw_count_503 = _tw_count_503 + 1;
      end
    end

    // phi2 rise at 2770.2 ns
    @(timer(2770200000e-15 * time_scale, 10000000000e-15 * time_scale)) begin
      if ((cycles == 0) || (_tw_count_504 < cycles)) begin
        _tw_level_3 = 1;
        if (cycles > 0) _tw_count_504 = _tw_count_504 + 1;
      end
    end

    // phi2 fall at 2799.8 ns
    @(timer(2799800000e-15 * time_scale, 10000000000e-15 * time_scale)) begin
      if ((cycles == 0) || (_tw_count_505 < cycles)) begin
        _tw_level_3 = 0;
        if (cycles > 0) _tw_count_505 = _tw_count_505 + 1;
      end
    end

    // phi2 rise at 2820.2 ns
    @(timer(2820200000e-15 * time_scale, 10000000000e-15 * time_scale)) begin
      if ((cycles == 0) || (_tw_count_506 < cycles)) begin
        _tw_level_3 = 1;
        if (cycles > 0) _tw_count_506 = _tw_count_506 + 1;
      end
    end

    // phi2 fall at 2849.8 ns
    @(timer(2849800000e-15 * time_scale, 10000000000e-15 * time_scale)) begin
      if ((cycles == 0) || (_tw_count_507 < cycles)) begin
        _tw_level_3 = 0;
        if (cycles > 0) _tw_count_507 = _tw_count_507 + 1;
      end
    end

    // phi2 rise at 2870.2 ns
    @(timer(2870200000e-15 * time_scale, 10000000000e-15 * time_scale)) begin
      if ((cycles == 0) || (_tw_count_508 < cycles)) begin
        _tw_level_3 = 1;
        if (cycles > 0) _tw_count_508 = _tw_count_508 + 1;
      end
    end

    // phi2 fall at 2899.8 ns
    @(timer(2899800000e-15 * time_scale, 10000000000e-15 * time_scale)) begin
      if ((cycles == 0) || (_tw_count_509 < cycles)) begin
        _tw_level_3 = 0;
        if (cycles > 0) _tw_count_509 = _tw_count_509 + 1;
      end
    end

    // phi2 rise at 2920.2 ns
    @(timer(2920200000e-15 * time_scale, 10000000000e-15 * time_scale)) begin
      if ((cycles == 0) || (_tw_count_510 < cycles)) begin
        _tw_level_3 = 1;
        if (cycles > 0) _tw_count_510 = _tw_count_510 + 1;
      end
    end

    // phi2 fall at 2949.8 ns
    @(timer(2949800000e-15 * time_scale, 10000000000e-15 * time_scale)) begin
      if ((cycles == 0) || (_tw_count_511 < cycles)) begin
        _tw_level_3 = 0;
        if (cycles > 0) _tw_count_511 = _tw_count_511 + 1;
      end
    end

    // phi2 rise at 2970.2 ns
    @(timer(2970200000e-15 * time_scale, 10000000000e-15 * time_scale)) begin
      if ((cycles == 0) || (_tw_count_512 < cycles)) begin
        _tw_level_3 = 1;
        if (cycles > 0) _tw_count_512 = _tw_count_512 + 1;
      end
    end

    // phi2 fall at 2999.8 ns
    @(timer(2999800000e-15 * time_scale, 10000000000e-15 * time_scale)) begin
      if ((cycles == 0) || (_tw_count_513 < cycles)) begin
        _tw_level_3 = 0;
        if (cycles > 0) _tw_count_513 = _tw_count_513 + 1;
      end
    end

    // phi2 rise at 3020.2 ns
    @(timer(3020200000e-15 * time_scale, 10000000000e-15 * time_scale)) begin
      if ((cycles == 0) || (_tw_count_514 < cycles)) begin
        _tw_level_3 = 1;
        if (cycles > 0) _tw_count_514 = _tw_count_514 + 1;
      end
    end

    // phi2 fall at 3049.8 ns
    @(timer(3049800000e-15 * time_scale, 10000000000e-15 * time_scale)) begin
      if ((cycles == 0) || (_tw_count_515 < cycles)) begin
        _tw_level_3 = 0;
        if (cycles > 0) _tw_count_515 = _tw_count_515 + 1;
      end
    end

    // phi2 rise at 3070.2 ns
    @(timer(3070200000e-15 * time_scale, 10000000000e-15 * time_scale)) begin
      if ((cycles == 0) || (_tw_count_516 < cycles)) begin
        _tw_level_3 = 1;
        if (cycles > 0) _tw_count_516 = _tw_count_516 + 1;
      end
    end

    // phi2 fall at 3099.8 ns
    @(timer(3099800000e-15 * time_scale, 10000000000e-15 * time_scale)) begin
      if ((cycles == 0) || (_tw_count_517 < cycles)) begin
        _tw_level_3 = 0;
        if (cycles > 0) _tw_count_517 = _tw_count_517 + 1;
      end
    end

    // phi2 rise at 3120.2 ns
    @(timer(3120200000e-15 * time_scale, 10000000000e-15 * time_scale)) begin
      if ((cycles == 0) || (_tw_count_518 < cycles)) begin
        _tw_level_3 = 1;
        if (cycles > 0) _tw_count_518 = _tw_count_518 + 1;
      end
    end

    // phi2 fall at 3149.8 ns
    @(timer(3149800000e-15 * time_scale, 10000000000e-15 * time_scale)) begin
      if ((cycles == 0) || (_tw_count_519 < cycles)) begin
        _tw_level_3 = 0;
        if (cycles > 0) _tw_count_519 = _tw_count_519 + 1;
      end
    end

    // phi2 rise at 3170.2 ns
    @(timer(3170200000e-15 * time_scale, 10000000000e-15 * time_scale)) begin
      if ((cycles == 0) || (_tw_count_520 < cycles)) begin
        _tw_level_3 = 1;
        if (cycles > 0) _tw_count_520 = _tw_count_520 + 1;
      end
    end

    // phi2 fall at 3199.8 ns
    @(timer(3199800000e-15 * time_scale, 10000000000e-15 * time_scale)) begin
      if ((cycles == 0) || (_tw_count_521 < cycles)) begin
        _tw_level_3 = 0;
        if (cycles > 0) _tw_count_521 = _tw_count_521 + 1;
      end
    end

    // phi2 rise at 3220.2 ns
    @(timer(3220200000e-15 * time_scale, 10000000000e-15 * time_scale)) begin
      if ((cycles == 0) || (_tw_count_522 < cycles)) begin
        _tw_level_3 = 1;
        if (cycles > 0) _tw_count_522 = _tw_count_522 + 1;
      end
    end

    // phi2 fall at 3249.8 ns
    @(timer(3249800000e-15 * time_scale, 10000000000e-15 * time_scale)) begin
      if ((cycles == 0) || (_tw_count_523 < cycles)) begin
        _tw_level_3 = 0;
        if (cycles > 0) _tw_count_523 = _tw_count_523 + 1;
      end
    end

    // phi2 rise at 3270.2 ns
    @(timer(3270200000e-15 * time_scale, 10000000000e-15 * time_scale)) begin
      if ((cycles == 0) || (_tw_count_524 < cycles)) begin
        _tw_level_3 = 1;
        if (cycles > 0) _tw_count_524 = _tw_count_524 + 1;
      end
    end

    // phi2 fall at 3299.8 ns
    @(timer(3299800000e-15 * time_scale, 10000000000e-15 * time_scale)) begin
      if ((cycles == 0) || (_tw_count_525 < cycles)) begin
        _tw_level_3 = 0;
        if (cycles > 0) _tw_count_525 = _tw_count_525 + 1;
      end
    end

    // phi2 rise at 3320.2 ns
    @(timer(3320200000e-15 * time_scale, 10000000000e-15 * time_scale)) begin
      if ((cycles == 0) || (_tw_count_526 < cycles)) begin
        _tw_level_3 = 1;
        if (cycles > 0) _tw_count_526 = _tw_count_526 + 1;
      end
    end

    // phi2 fall at 3349.8 ns
    @(timer(3349800000e-15 * time_scale, 10000000000e-15 * time_scale)) begin
      if ((cycles == 0) || (_tw_count_527 < cycles)) begin
        _tw_level_3 = 0;
        if (cycles > 0) _tw_count_527 = _tw_count_527 + 1;
      end
    end

    // phi2 rise at 3370.2 ns
    @(timer(3370200000e-15 * time_scale, 10000000000e-15 * time_scale)) begin
      if ((cycles == 0) || (_tw_count_528 < cycles)) begin
        _tw_level_3 = 1;
        if (cycles > 0) _tw_count_528 = _tw_count_528 + 1;
      end
    end

    // phi2 fall at 3399.8 ns
    @(timer(3399800000e-15 * time_scale, 10000000000e-15 * time_scale)) begin
      if ((cycles == 0) || (_tw_count_529 < cycles)) begin
        _tw_level_3 = 0;
        if (cycles > 0) _tw_count_529 = _tw_count_529 + 1;
      end
    end

    // phi2 rise at 3420.2 ns
    @(timer(3420200000e-15 * time_scale, 10000000000e-15 * time_scale)) begin
      if ((cycles == 0) || (_tw_count_530 < cycles)) begin
        _tw_level_3 = 1;
        if (cycles > 0) _tw_count_530 = _tw_count_530 + 1;
      end
    end

    // phi2 fall at 3449.8 ns
    @(timer(3449800000e-15 * time_scale, 10000000000e-15 * time_scale)) begin
      if ((cycles == 0) || (_tw_count_531 < cycles)) begin
        _tw_level_3 = 0;
        if (cycles > 0) _tw_count_531 = _tw_count_531 + 1;
      end
    end

    // phi2 rise at 3470.2 ns
    @(timer(3470200000e-15 * time_scale, 10000000000e-15 * time_scale)) begin
      if ((cycles == 0) || (_tw_count_532 < cycles)) begin
        _tw_level_3 = 1;
        if (cycles > 0) _tw_count_532 = _tw_count_532 + 1;
      end
    end

    // phi2 fall at 3499.8 ns
    @(timer(3499800000e-15 * time_scale, 10000000000e-15 * time_scale)) begin
      if ((cycles == 0) || (_tw_count_533 < cycles)) begin
        _tw_level_3 = 0;
        if (cycles > 0) _tw_count_533 = _tw_count_533 + 1;
      end
    end

    // phi2 rise at 3520.2 ns
    @(timer(3520200000e-15 * time_scale, 10000000000e-15 * time_scale)) begin
      if ((cycles == 0) || (_tw_count_534 < cycles)) begin
        _tw_level_3 = 1;
        if (cycles > 0) _tw_count_534 = _tw_count_534 + 1;
      end
    end

    // phi2 fall at 3549.8 ns
    @(timer(3549800000e-15 * time_scale, 10000000000e-15 * time_scale)) begin
      if ((cycles == 0) || (_tw_count_535 < cycles)) begin
        _tw_level_3 = 0;
        if (cycles > 0) _tw_count_535 = _tw_count_535 + 1;
      end
    end

    // phi2 rise at 3570.2 ns
    @(timer(3570200000e-15 * time_scale, 10000000000e-15 * time_scale)) begin
      if ((cycles == 0) || (_tw_count_536 < cycles)) begin
        _tw_level_3 = 1;
        if (cycles > 0) _tw_count_536 = _tw_count_536 + 1;
      end
    end

    // phi2 fall at 3599.8 ns
    @(timer(3599800000e-15 * time_scale, 10000000000e-15 * time_scale)) begin
      if ((cycles == 0) || (_tw_count_537 < cycles)) begin
        _tw_level_3 = 0;
        if (cycles > 0) _tw_count_537 = _tw_count_537 + 1;
      end
    end

    // phi2 rise at 3620.2 ns
    @(timer(3620200000e-15 * time_scale, 10000000000e-15 * time_scale)) begin
      if ((cycles == 0) || (_tw_count_538 < cycles)) begin
        _tw_level_3 = 1;
        if (cycles > 0) _tw_count_538 = _tw_count_538 + 1;
      end
    end

    // phi2 fall at 3649.8 ns
    @(timer(3649800000e-15 * time_scale, 10000000000e-15 * time_scale)) begin
      if ((cycles == 0) || (_tw_count_539 < cycles)) begin
        _tw_level_3 = 0;
        if (cycles > 0) _tw_count_539 = _tw_count_539 + 1;
      end
    end

    // phi2 rise at 3670.2 ns
    @(timer(3670200000e-15 * time_scale, 10000000000e-15 * time_scale)) begin
      if ((cycles == 0) || (_tw_count_540 < cycles)) begin
        _tw_level_3 = 1;
        if (cycles > 0) _tw_count_540 = _tw_count_540 + 1;
      end
    end

    // phi2 fall at 3699.8 ns
    @(timer(3699800000e-15 * time_scale, 10000000000e-15 * time_scale)) begin
      if ((cycles == 0) || (_tw_count_541 < cycles)) begin
        _tw_level_3 = 0;
        if (cycles > 0) _tw_count_541 = _tw_count_541 + 1;
      end
    end

    // phi2 rise at 3720.2 ns
    @(timer(3720200000e-15 * time_scale, 10000000000e-15 * time_scale)) begin
      if ((cycles == 0) || (_tw_count_542 < cycles)) begin
        _tw_level_3 = 1;
        if (cycles > 0) _tw_count_542 = _tw_count_542 + 1;
      end
    end

    // phi2 fall at 3749.8 ns
    @(timer(3749800000e-15 * time_scale, 10000000000e-15 * time_scale)) begin
      if ((cycles == 0) || (_tw_count_543 < cycles)) begin
        _tw_level_3 = 0;
        if (cycles > 0) _tw_count_543 = _tw_count_543 + 1;
      end
    end

    // phi2 rise at 3770.2 ns
    @(timer(3770200000e-15 * time_scale, 10000000000e-15 * time_scale)) begin
      if ((cycles == 0) || (_tw_count_544 < cycles)) begin
        _tw_level_3 = 1;
        if (cycles > 0) _tw_count_544 = _tw_count_544 + 1;
      end
    end

    // phi2 fall at 3799.8 ns
    @(timer(3799800000e-15 * time_scale, 10000000000e-15 * time_scale)) begin
      if ((cycles == 0) || (_tw_count_545 < cycles)) begin
        _tw_level_3 = 0;
        if (cycles > 0) _tw_count_545 = _tw_count_545 + 1;
      end
    end

    // phi2 rise at 3820.2 ns
    @(timer(3820200000e-15 * time_scale, 10000000000e-15 * time_scale)) begin
      if ((cycles == 0) || (_tw_count_546 < cycles)) begin
        _tw_level_3 = 1;
        if (cycles > 0) _tw_count_546 = _tw_count_546 + 1;
      end
    end

    // phi2 fall at 3849.8 ns
    @(timer(3849800000e-15 * time_scale, 10000000000e-15 * time_scale)) begin
      if ((cycles == 0) || (_tw_count_547 < cycles)) begin
        _tw_level_3 = 0;
        if (cycles > 0) _tw_count_547 = _tw_count_547 + 1;
      end
    end

    // phi2 rise at 3870.2 ns
    @(timer(3870200000e-15 * time_scale, 10000000000e-15 * time_scale)) begin
      if ((cycles == 0) || (_tw_count_548 < cycles)) begin
        _tw_level_3 = 1;
        if (cycles > 0) _tw_count_548 = _tw_count_548 + 1;
      end
    end

    // phi2 fall at 3899.8 ns
    @(timer(3899800000e-15 * time_scale, 10000000000e-15 * time_scale)) begin
      if ((cycles == 0) || (_tw_count_549 < cycles)) begin
        _tw_level_3 = 0;
        if (cycles > 0) _tw_count_549 = _tw_count_549 + 1;
      end
    end

    // phi2 rise at 3920.2 ns
    @(timer(3920200000e-15 * time_scale, 10000000000e-15 * time_scale)) begin
      if ((cycles == 0) || (_tw_count_550 < cycles)) begin
        _tw_level_3 = 1;
        if (cycles > 0) _tw_count_550 = _tw_count_550 + 1;
      end
    end

    // phi2 fall at 3949.8 ns
    @(timer(3949800000e-15 * time_scale, 10000000000e-15 * time_scale)) begin
      if ((cycles == 0) || (_tw_count_551 < cycles)) begin
        _tw_level_3 = 0;
        if (cycles > 0) _tw_count_551 = _tw_count_551 + 1;
      end
    end

    // phi2 rise at 3970.2 ns
    @(timer(3970200000e-15 * time_scale, 10000000000e-15 * time_scale)) begin
      if ((cycles == 0) || (_tw_count_552 < cycles)) begin
        _tw_level_3 = 1;
        if (cycles > 0) _tw_count_552 = _tw_count_552 + 1;
      end
    end

    // phi2 fall at 3999.8 ns
    @(timer(3999800000e-15 * time_scale, 10000000000e-15 * time_scale)) begin
      if ((cycles == 0) || (_tw_count_553 < cycles)) begin
        _tw_level_3 = 0;
        if (cycles > 0) _tw_count_553 = _tw_count_553 + 1;
      end
    end

    // phi2 rise at 4020.2 ns
    @(timer(4020200000e-15 * time_scale, 10000000000e-15 * time_scale)) begin
      if ((cycles == 0) || (_tw_count_554 < cycles)) begin
        _tw_level_3 = 1;
        if (cycles > 0) _tw_count_554 = _tw_count_554 + 1;
      end
    end

    // phi2 fall at 4049.8 ns
    @(timer(4049800000e-15 * time_scale, 10000000000e-15 * time_scale)) begin
      if ((cycles == 0) || (_tw_count_555 < cycles)) begin
        _tw_level_3 = 0;
        if (cycles > 0) _tw_count_555 = _tw_count_555 + 1;
      end
    end

    // phi2 rise at 4070.2 ns
    @(timer(4070200000e-15 * time_scale, 10000000000e-15 * time_scale)) begin
      if ((cycles == 0) || (_tw_count_556 < cycles)) begin
        _tw_level_3 = 1;
        if (cycles > 0) _tw_count_556 = _tw_count_556 + 1;
      end
    end

    // phi2 fall at 4099.8 ns
    @(timer(4099800000e-15 * time_scale, 10000000000e-15 * time_scale)) begin
      if ((cycles == 0) || (_tw_count_557 < cycles)) begin
        _tw_level_3 = 0;
        if (cycles > 0) _tw_count_557 = _tw_count_557 + 1;
      end
    end

    // phi2 rise at 4120.2 ns
    @(timer(4120200000e-15 * time_scale, 10000000000e-15 * time_scale)) begin
      if ((cycles == 0) || (_tw_count_558 < cycles)) begin
        _tw_level_3 = 1;
        if (cycles > 0) _tw_count_558 = _tw_count_558 + 1;
      end
    end

    // phi2 fall at 4149.8 ns
    @(timer(4149800000e-15 * time_scale, 10000000000e-15 * time_scale)) begin
      if ((cycles == 0) || (_tw_count_559 < cycles)) begin
        _tw_level_3 = 0;
        if (cycles > 0) _tw_count_559 = _tw_count_559 + 1;
      end
    end

    // phi2 rise at 4170.2 ns
    @(timer(4170200000e-15 * time_scale, 10000000000e-15 * time_scale)) begin
      if ((cycles == 0) || (_tw_count_560 < cycles)) begin
        _tw_level_3 = 1;
        if (cycles > 0) _tw_count_560 = _tw_count_560 + 1;
      end
    end

    // phi2 fall at 4199.8 ns
    @(timer(4199800000e-15 * time_scale, 10000000000e-15 * time_scale)) begin
      if ((cycles == 0) || (_tw_count_561 < cycles)) begin
        _tw_level_3 = 0;
        if (cycles > 0) _tw_count_561 = _tw_count_561 + 1;
      end
    end

    // phi2 rise at 4220.2 ns
    @(timer(4220200000e-15 * time_scale, 10000000000e-15 * time_scale)) begin
      if ((cycles == 0) || (_tw_count_562 < cycles)) begin
        _tw_level_3 = 1;
        if (cycles > 0) _tw_count_562 = _tw_count_562 + 1;
      end
    end

    // phi2 fall at 4249.8 ns
    @(timer(4249800000e-15 * time_scale, 10000000000e-15 * time_scale)) begin
      if ((cycles == 0) || (_tw_count_563 < cycles)) begin
        _tw_level_3 = 0;
        if (cycles > 0) _tw_count_563 = _tw_count_563 + 1;
      end
    end

    // phi2 rise at 4270.2 ns
    @(timer(4270200000e-15 * time_scale, 10000000000e-15 * time_scale)) begin
      if ((cycles == 0) || (_tw_count_564 < cycles)) begin
        _tw_level_3 = 1;
        if (cycles > 0) _tw_count_564 = _tw_count_564 + 1;
      end
    end

    // phi2 fall at 4299.8 ns
    @(timer(4299800000e-15 * time_scale, 10000000000e-15 * time_scale)) begin
      if ((cycles == 0) || (_tw_count_565 < cycles)) begin
        _tw_level_3 = 0;
        if (cycles > 0) _tw_count_565 = _tw_count_565 + 1;
      end
    end

    // phi2 rise at 4320.2 ns
    @(timer(4320200000e-15 * time_scale, 10000000000e-15 * time_scale)) begin
      if ((cycles == 0) || (_tw_count_566 < cycles)) begin
        _tw_level_3 = 1;
        if (cycles > 0) _tw_count_566 = _tw_count_566 + 1;
      end
    end

    // phi2 fall at 4349.8 ns
    @(timer(4349800000e-15 * time_scale, 10000000000e-15 * time_scale)) begin
      if ((cycles == 0) || (_tw_count_567 < cycles)) begin
        _tw_level_3 = 0;
        if (cycles > 0) _tw_count_567 = _tw_count_567 + 1;
      end
    end

    // phi2 rise at 4370.2 ns
    @(timer(4370200000e-15 * time_scale, 10000000000e-15 * time_scale)) begin
      if ((cycles == 0) || (_tw_count_568 < cycles)) begin
        _tw_level_3 = 1;
        if (cycles > 0) _tw_count_568 = _tw_count_568 + 1;
      end
    end

    // phi2 fall at 4399.8 ns
    @(timer(4399800000e-15 * time_scale, 10000000000e-15 * time_scale)) begin
      if ((cycles == 0) || (_tw_count_569 < cycles)) begin
        _tw_level_3 = 0;
        if (cycles > 0) _tw_count_569 = _tw_count_569 + 1;
      end
    end

    // phi2 rise at 4420.2 ns
    @(timer(4420200000e-15 * time_scale, 10000000000e-15 * time_scale)) begin
      if ((cycles == 0) || (_tw_count_570 < cycles)) begin
        _tw_level_3 = 1;
        if (cycles > 0) _tw_count_570 = _tw_count_570 + 1;
      end
    end

    // phi2 fall at 4449.8 ns
    @(timer(4449800000e-15 * time_scale, 10000000000e-15 * time_scale)) begin
      if ((cycles == 0) || (_tw_count_571 < cycles)) begin
        _tw_level_3 = 0;
        if (cycles > 0) _tw_count_571 = _tw_count_571 + 1;
      end
    end

    // phi2 rise at 4470.2 ns
    @(timer(4470200000e-15 * time_scale, 10000000000e-15 * time_scale)) begin
      if ((cycles == 0) || (_tw_count_572 < cycles)) begin
        _tw_level_3 = 1;
        if (cycles > 0) _tw_count_572 = _tw_count_572 + 1;
      end
    end

    // phi2 fall at 4499.8 ns
    @(timer(4499800000e-15 * time_scale, 10000000000e-15 * time_scale)) begin
      if ((cycles == 0) || (_tw_count_573 < cycles)) begin
        _tw_level_3 = 0;
        if (cycles > 0) _tw_count_573 = _tw_count_573 + 1;
      end
    end

    // phi2 rise at 4520.2 ns
    @(timer(4520200000e-15 * time_scale, 10000000000e-15 * time_scale)) begin
      if ((cycles == 0) || (_tw_count_574 < cycles)) begin
        _tw_level_3 = 1;
        if (cycles > 0) _tw_count_574 = _tw_count_574 + 1;
      end
    end

    // phi2 fall at 4549.8 ns
    @(timer(4549800000e-15 * time_scale, 10000000000e-15 * time_scale)) begin
      if ((cycles == 0) || (_tw_count_575 < cycles)) begin
        _tw_level_3 = 0;
        if (cycles > 0) _tw_count_575 = _tw_count_575 + 1;
      end
    end

    // phi2 rise at 4570.2 ns
    @(timer(4570200000e-15 * time_scale, 10000000000e-15 * time_scale)) begin
      if ((cycles == 0) || (_tw_count_576 < cycles)) begin
        _tw_level_3 = 1;
        if (cycles > 0) _tw_count_576 = _tw_count_576 + 1;
      end
    end

    // phi2 fall at 4599.8 ns
    @(timer(4599800000e-15 * time_scale, 10000000000e-15 * time_scale)) begin
      if ((cycles == 0) || (_tw_count_577 < cycles)) begin
        _tw_level_3 = 0;
        if (cycles > 0) _tw_count_577 = _tw_count_577 + 1;
      end
    end

    // phi2 rise at 4620.2 ns
    @(timer(4620200000e-15 * time_scale, 10000000000e-15 * time_scale)) begin
      if ((cycles == 0) || (_tw_count_578 < cycles)) begin
        _tw_level_3 = 1;
        if (cycles > 0) _tw_count_578 = _tw_count_578 + 1;
      end
    end

    // phi2 fall at 4649.8 ns
    @(timer(4649800000e-15 * time_scale, 10000000000e-15 * time_scale)) begin
      if ((cycles == 0) || (_tw_count_579 < cycles)) begin
        _tw_level_3 = 0;
        if (cycles > 0) _tw_count_579 = _tw_count_579 + 1;
      end
    end

    // phi2 rise at 4670.2 ns
    @(timer(4670200000e-15 * time_scale, 10000000000e-15 * time_scale)) begin
      if ((cycles == 0) || (_tw_count_580 < cycles)) begin
        _tw_level_3 = 1;
        if (cycles > 0) _tw_count_580 = _tw_count_580 + 1;
      end
    end

    // phi2 fall at 4699.8 ns
    @(timer(4699800000e-15 * time_scale, 10000000000e-15 * time_scale)) begin
      if ((cycles == 0) || (_tw_count_581 < cycles)) begin
        _tw_level_3 = 0;
        if (cycles > 0) _tw_count_581 = _tw_count_581 + 1;
      end
    end

    // phi2 rise at 4720.2 ns
    @(timer(4720200000e-15 * time_scale, 10000000000e-15 * time_scale)) begin
      if ((cycles == 0) || (_tw_count_582 < cycles)) begin
        _tw_level_3 = 1;
        if (cycles > 0) _tw_count_582 = _tw_count_582 + 1;
      end
    end

    // phi2 fall at 4749.8 ns
    @(timer(4749800000e-15 * time_scale, 10000000000e-15 * time_scale)) begin
      if ((cycles == 0) || (_tw_count_583 < cycles)) begin
        _tw_level_3 = 0;
        if (cycles > 0) _tw_count_583 = _tw_count_583 + 1;
      end
    end

    // phi2 rise at 4770.2 ns
    @(timer(4770200000e-15 * time_scale, 10000000000e-15 * time_scale)) begin
      if ((cycles == 0) || (_tw_count_584 < cycles)) begin
        _tw_level_3 = 1;
        if (cycles > 0) _tw_count_584 = _tw_count_584 + 1;
      end
    end

    // phi2 fall at 4799.8 ns
    @(timer(4799800000e-15 * time_scale, 10000000000e-15 * time_scale)) begin
      if ((cycles == 0) || (_tw_count_585 < cycles)) begin
        _tw_level_3 = 0;
        if (cycles > 0) _tw_count_585 = _tw_count_585 + 1;
      end
    end

    // phi2 rise at 4820.2 ns
    @(timer(4820200000e-15 * time_scale, 10000000000e-15 * time_scale)) begin
      if ((cycles == 0) || (_tw_count_586 < cycles)) begin
        _tw_level_3 = 1;
        if (cycles > 0) _tw_count_586 = _tw_count_586 + 1;
      end
    end

    // phi2 fall at 4849.8 ns
    @(timer(4849800000e-15 * time_scale, 10000000000e-15 * time_scale)) begin
      if ((cycles == 0) || (_tw_count_587 < cycles)) begin
        _tw_level_3 = 0;
        if (cycles > 0) _tw_count_587 = _tw_count_587 + 1;
      end
    end

    // phi2 rise at 4870.2 ns
    @(timer(4870200000e-15 * time_scale, 10000000000e-15 * time_scale)) begin
      if ((cycles == 0) || (_tw_count_588 < cycles)) begin
        _tw_level_3 = 1;
        if (cycles > 0) _tw_count_588 = _tw_count_588 + 1;
      end
    end

    // phi2 fall at 4899.8 ns
    @(timer(4899800000e-15 * time_scale, 10000000000e-15 * time_scale)) begin
      if ((cycles == 0) || (_tw_count_589 < cycles)) begin
        _tw_level_3 = 0;
        if (cycles > 0) _tw_count_589 = _tw_count_589 + 1;
      end
    end

    // phi2 rise at 4920.2 ns
    @(timer(4920200000e-15 * time_scale, 10000000000e-15 * time_scale)) begin
      if ((cycles == 0) || (_tw_count_590 < cycles)) begin
        _tw_level_3 = 1;
        if (cycles > 0) _tw_count_590 = _tw_count_590 + 1;
      end
    end

    // phi2 fall at 4949.8 ns
    @(timer(4949800000e-15 * time_scale, 10000000000e-15 * time_scale)) begin
      if ((cycles == 0) || (_tw_count_591 < cycles)) begin
        _tw_level_3 = 0;
        if (cycles > 0) _tw_count_591 = _tw_count_591 + 1;
      end
    end

    // phi2 rise at 4970.2 ns
    @(timer(4970200000e-15 * time_scale, 10000000000e-15 * time_scale)) begin
      if ((cycles == 0) || (_tw_count_592 < cycles)) begin
        _tw_level_3 = 1;
        if (cycles > 0) _tw_count_592 = _tw_count_592 + 1;
      end
    end

    // phi2 fall at 4999.8 ns
    @(timer(4999800000e-15 * time_scale, 10000000000e-15 * time_scale)) begin
      if ((cycles == 0) || (_tw_count_593 < cycles)) begin
        _tw_level_3 = 0;
        if (cycles > 0) _tw_count_593 = _tw_count_593 + 1;
      end
    end

    // phi2 rise at 5020.2 ns
    @(timer(5020200000e-15 * time_scale, 10000000000e-15 * time_scale)) begin
      if ((cycles == 0) || (_tw_count_594 < cycles)) begin
        _tw_level_3 = 1;
        if (cycles > 0) _tw_count_594 = _tw_count_594 + 1;
      end
    end

    // phi2 fall at 5049.8 ns
    @(timer(5049800000e-15 * time_scale, 10000000000e-15 * time_scale)) begin
      if ((cycles == 0) || (_tw_count_595 < cycles)) begin
        _tw_level_3 = 0;
        if (cycles > 0) _tw_count_595 = _tw_count_595 + 1;
      end
    end

    // phi2 rise at 5070.2 ns
    @(timer(5070200000e-15 * time_scale, 10000000000e-15 * time_scale)) begin
      if ((cycles == 0) || (_tw_count_596 < cycles)) begin
        _tw_level_3 = 1;
        if (cycles > 0) _tw_count_596 = _tw_count_596 + 1;
      end
    end

    // phi2 fall at 5099.8 ns
    @(timer(5099800000e-15 * time_scale, 10000000000e-15 * time_scale)) begin
      if ((cycles == 0) || (_tw_count_597 < cycles)) begin
        _tw_level_3 = 0;
        if (cycles > 0) _tw_count_597 = _tw_count_597 + 1;
      end
    end

    // phi2 rise at 5120.2 ns
    @(timer(5120200000e-15 * time_scale, 10000000000e-15 * time_scale)) begin
      if ((cycles == 0) || (_tw_count_598 < cycles)) begin
        _tw_level_3 = 1;
        if (cycles > 0) _tw_count_598 = _tw_count_598 + 1;
      end
    end

    // phi2 fall at 5149.8 ns
    @(timer(5149800000e-15 * time_scale, 10000000000e-15 * time_scale)) begin
      if ((cycles == 0) || (_tw_count_599 < cycles)) begin
        _tw_level_3 = 0;
        if (cycles > 0) _tw_count_599 = _tw_count_599 + 1;
      end
    end

    // phi2 rise at 5170.2 ns
    @(timer(5170200000e-15 * time_scale, 10000000000e-15 * time_scale)) begin
      if ((cycles == 0) || (_tw_count_600 < cycles)) begin
        _tw_level_3 = 1;
        if (cycles > 0) _tw_count_600 = _tw_count_600 + 1;
      end
    end

    // phi2 fall at 5199.8 ns
    @(timer(5199800000e-15 * time_scale, 10000000000e-15 * time_scale)) begin
      if ((cycles == 0) || (_tw_count_601 < cycles)) begin
        _tw_level_3 = 0;
        if (cycles > 0) _tw_count_601 = _tw_count_601 + 1;
      end
    end

    // sample rise at 600 ns
    @(timer(600000000e-15 * time_scale, 10000000000e-15 * time_scale)) begin
      if ((cycles == 0) || (_tw_count_602 < cycles)) begin
        _tw_level_4 = 1;
        if (cycles > 0) _tw_count_602 = _tw_count_602 + 1;
      end
    end

    // sample fall at 1000 ns
    @(timer(1000000000e-15 * time_scale, 10000000000e-15 * time_scale)) begin
      if ((cycles == 0) || (_tw_count_603 < cycles)) begin
        _tw_level_4 = 0;
        if (cycles > 0) _tw_count_603 = _tw_count_603 + 1;
      end
    end

    // sample rise at 1400 ns
    @(timer(1400000000e-15 * time_scale, 10000000000e-15 * time_scale)) begin
      if ((cycles == 0) || (_tw_count_604 < cycles)) begin
        _tw_level_4 = 1;
        if (cycles > 0) _tw_count_604 = _tw_count_604 + 1;
      end
    end

    // sample fall at 1800 ns
    @(timer(1800000000e-15 * time_scale, 10000000000e-15 * time_scale)) begin
      if ((cycles == 0) || (_tw_count_605 < cycles)) begin
        _tw_level_4 = 0;
        if (cycles > 0) _tw_count_605 = _tw_count_605 + 1;
      end
    end

    // done rise at 5220 ns
    @(timer(5220000000e-15 * time_scale, 10000000000e-15 * time_scale)) begin
      if ((cycles == 0) || (_tw_count_606 < cycles)) begin
        _tw_level_5 = 1;
        if (cycles > 0) _tw_count_606 = _tw_count_606 + 1;
      end
    end

    // done fall at 5320 ns
    @(timer(5320000000e-15 * time_scale, 10000000000e-15 * time_scale)) begin
      if ((cycles == 0) || (_tw_count_607 < cycles)) begin
        _tw_level_5 = 0;
        if (cycles > 0) _tw_count_607 = _tw_count_607 + 1;
      end
    end

    V(reset, vref) <+ transition(_tw_level_0 ? vhigh : vlow, 0.0, trise * time_scale, tfall * time_scale);
    V(clk, vref) <+ transition(_tw_level_1 ? vhigh : vlow, 0.0, trise * time_scale, tfall * time_scale);
    V(phi1, vref) <+ transition(_tw_level_2 ? vhigh : vlow, 0.0, trise * time_scale, tfall * time_scale);
    V(phi2, vref) <+ transition(_tw_level_3 ? vhigh : vlow, 0.0, trise * time_scale, tfall * time_scale);
    V(sample, vref) <+ transition(_tw_level_4 ? vhigh : vlow, 0.0, trise * time_scale, tfall * time_scale);
    V(done, vref) <+ transition(_tw_level_5 ? vhigh : vlow, 0.0, trise * time_scale, tfall * time_scale);
  end
endmodule
